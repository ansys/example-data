# Ansys Electronics Desktop project, version 2023.1
materials:
  FR4_epoxy: permittivity=4.4 dielectric_loss_tangent=0.02
  Rogers RT/duroid 5880 (tm): permittivity=2.2 dielectric_loss_tangent=0.0009
  vacuum: permittivity=1

design with_chassis_em (HFSS, Eigenmode, model units mm)
options: Save_Adaptive_support_files
variables:
  ltr = 17.2mm*2.
  wtr = 2.4mm
  R_term = 50ohm
  abox = 160mm
  l_diff = 0mm
  term = 50ohm
  R1 = 50ohm
  R2 = 50ohm
geometry:
  substrate [FR4_epoxy] = box(corner=(-45mm, -25mm, 0mm), size=(90mm, 50mm, -1.6mm))
  ground [Rogers RT/duroid 5880 (tm)] = object_from(substrate.face(-z))
  trace1 [Rogers RT/duroid 5880 (tm)] = rectangle(corner=(-ltr/2, -wtr/2, 0mm), x_size=ltr, y_size=wtr)
  trace1.move(0mm, -wtr, 0mm)
  trace2 [Rogers RT/duroid 5880 (tm)] = trace1.duplicate_along_line(step=(0mm, 2*wtr, 0mm), total=2)
  port1 [Rogers RT/duroid 5880 (tm)] = rectangle(corner=(ltr/2, -wtr/2, 0mm), y_size=wtr, z_size=-1.6mm)
  term1 [Rogers RT/duroid 5880 (tm)] = port1.duplicate_along_line(step=(-ltr, 0mm, 0mm), total=2)
  port1.move(0mm, -wtr, 0mm)
  port2 [Rogers RT/duroid 5880 (tm)] = port1.duplicate_along_line(step=(0mm, 2*wtr, 0mm), total=2)
  term1.move(0mm, -wtr, 0mm)
  term2 [Rogers RT/duroid 5880 (tm)] = term1.duplicate_along_line(step=(0mm, 2*wtr, 0mm), total=2)
  Airbox [vacuum] = box(corner=(-abox/2, -abox/2, -40mm), size=(abox, abox, 80mm))
  trace2.move_edges(MoveAlongNormalFlag=true OffsetDistance=l_diff EdgesToMove=trace2.edge(4 of 4))
  term2.move(-l_diff, 0mm, 0mm)
  chassis1 = component(HFSSDesign1, 3D_Component_File_Path=D:/customers/Bosch/shield/Radiated_Emissions_From_Chassis/chassis.a3dcomp)
  chassis, frount_face [vacuum] = part_of(chassis1)
boundaries and excitations:
  chassis1_box: Perfect E Faces=chassis.face(at (-50.625, 18.0568, 0), at (8.4375, 0, -5.175), at (8.4375, 61.25, 0), at (8.4375, 0, 5.175), at (-15.6827, -36.125, 0), at (27.875, -54.75, 0), at (47.6875, -61.25, 0), at (10.875, -42.1875, 0), at (-25.2403, -30.6307, 0), at (-37.9327, -25.1363, 0))
  chassis1_front: Perfect E Objects=frount_face
  PerfE1: Perfect E Objects=[trace1, trace2, ground]
  LumpRLC1: Lumped RLC Objects=term1 CurrentLine{(-17.2, -2.4, -1.6) -> (-17.2, -2.4, 0)} RLC_Type=Parallel Resistance=R1
  LumpRLC2: Lumped RLC Objects=term2 CurrentLine{(-17.2, 2.4, -1.6) -> (-17.2, 2.4, 0)} RLC_Type=Parallel Resistance=R2
  LumpRLC3: Lumped RLC Objects=port1 CurrentLine{(17.2, -2.4, -1.6) -> (17.2, -2.4, 0)} RLC_Type=Parallel Resistance=R1
  LumpRLC4: Lumped RLC Objects=port2 CurrentLine{(17.2, 2.4, -1.6) -> (17.2, 2.4, 0)} RLC_Type=Parallel Resistance=R2
  Layered1: Layered Impedance Faces=Airbox.face(all 6) Frequency=0GHz Layers{Layer1{LayerType=1 Thickness=1um Material=vacuum}}
  reference conductors: ground
source amplitudes:
  #-10:1: 1 0deg
