# Ansys Electronics Desktop project, version 2026.1
materials:
  vacuum: permittivity=1
  copper: permeability=0.999991 conductivity=58000000
  Al-Extruded
  air: permittivity=1.0006 permeability=1.0000004
  epoxy_Kevlar_xy: permittivity=3.6
  polyethylene: permittivity=2.25 dielectric_loss_tangent=0.001
  Al2_O3_ceramic: permittivity=9.8
  polyethylene_multiphysics: permittivity=2.25 dielectric_loss_tangent=0.001
  steel_1008: permeability{HUnit=A_per_meter BUnit=tesla curve (0, 0) (159.2, 0.2402) (318.3, 0.8654) (477.5, 1.1106) (636.6, 1.2458) (795.8, 1.331) (1591.5, 1.5) (3183.1, 1.6) (4774.6, 1.683) (6366.2, 1.741) (7957.7, 1.78) (15915.5, 1.905) (31831, 2.025) (47746.5, 2.085) (63662, 2.13) (79577.5, 2.165) (159155, 2.28) (318310, 2.485) (397887, 2.5851)} conductivity=2000000
surface materials:
  Steel-oxidised-surface

design Q3DDesign (Q3D Extractor, model units mm)
options: SParamCalcMethod=EqTransLine Calculate_Lossy_Dielectrics
variables:
  I_DC = 10A
geometry:
  FUSE_DIELECTRIC3 [polyethylene, non-model] = imported_body(C:\Users\mabarham\Desktop\Q3D-Icepak WS\MCAD\bb_circuit_asm_revised_Jan2019_final.stp)
  FUSE_METAL3 [copper, non-model] = imported_body(C:\Users\mabarham\Desktop\Q3D-Icepak WS\MCAD\bb_circuit_asm_revised_Jan2019_final.stp)
  FUSE_DIELECTRIC2 [polyethylene_multiphysics] = imported_body(C:\Users\mabarham\Desktop\Q3D-Icepak WS\MCAD\bb_circuit_asm_revised_Jan2019_final.stp)
  FUSE_METAL2 = imported_body(C:\Users\mabarham\Desktop\Q3D-Icepak WS\MCAD\bb_circuit_asm_revised_Jan2019_final.stp)
  FUSE_DIELECTRIC1 [polyethylene, non-model] = imported_body(C:\Users\mabarham\Desktop\Q3D-Icepak WS\MCAD\bb_circuit_asm_revised_Jan2019_final.stp)
  FUSE_METAL1 [copper, non-model] = imported_body(C:\Users\mabarham\Desktop\Q3D-Icepak WS\MCAD\bb_circuit_asm_revised_Jan2019_final.stp)
  BB2 [copper] = imported_body(C:\Users\mabarham\Desktop\Q3D-Icepak WS\MCAD\bb_circuit_asm_revised_Jan2019_final.stp)
  BB1, BB3, STUD3_1 [copper, non-model] = imported_body(C:\Users\mabarham\Desktop\Q3D-Icepak WS\MCAD\bb_circuit_asm_revised_Jan2019_final.stp)
  STUD2_1 [copper] = imported_body(C:\Users\mabarham\Desktop\Q3D-Icepak WS\MCAD\bb_circuit_asm_revised_Jan2019_final.stp)
  STUD1_1, STUD3_2 [copper, non-model] = imported_body(C:\Users\mabarham\Desktop\Q3D-Icepak WS\MCAD\bb_circuit_asm_revised_Jan2019_final.stp)
  STUD2_2 [copper] = imported_body(C:\Users\mabarham\Desktop\Q3D-Icepak WS\MCAD\bb_circuit_asm_revised_Jan2019_final.stp)
  STUD1_2 [copper, non-model] = imported_body(C:\Users\mabarham\Desktop\Q3D-Icepak WS\MCAD\bb_circuit_asm_revised_Jan2019_final.stp)
  BB2_DS [copper] = imported_body(C:\Users\mabarham\Desktop\Q3D-Icepak WS\MCAD\bb_circuit_asm_revised_Jan2019_final.stp)
  BB1_DS, BB3_DS [copper, non-model] = imported_body(C:\Users\mabarham\Desktop\Q3D-Icepak WS\MCAD\bb_circuit_asm_revised_Jan2019_final.stp)
  DOWNSTREAM_FUSE_BOX, COVER_FUSE_BOX [polyethylene, non-model] = imported_body(C:\Users\mabarham\Desktop\Q3D-Icepak WS\MCAD\bb_circuit_asm_revised_Jan2019_final.stp)
  FUSE_METAL2_Split1 = FUSE_METAL2.split(plane=?.face(#442), keep=Both)
  FUSE_METAL2.split(plane=?.face(#428), keep=PositiveOnly)
  Fuse_METAL2_1 [copper] = box(corner=(-35.8mm, 154.21mm, 49.715mm), size=(-1mm, -8.82mm, 2.57mm))
  Fuse_METAL2_1.unite(FUSE_METAL2_Split1, FUSE_METAL2)
  list BB2_DS_fixed1 = BB2_DS.face(at (35.2, 262.3, 191), at (35.2, 262.3, 195))
  list BB2_DS_fixed2 = BB2_DS.face(at (35.2, 262.3, 170), at (35.2, 262.3, 174))
  list BB2_DS_fixed3 = BB2_DS.face(at (35.2, 262.3, 149), at (35.2, 262.3, 153))
  group bb_circuit_asm = FUSE_DIELECTRIC3, FUSE_METAL3, FUSE_DIELECTRIC2, FUSE_DIELECTRIC1, FUSE_METAL1, BB2, BB1, BB3, STUD3_1, STUD2_1, STUD1_1, STUD3_2, STUD2_2, STUD1_2, BB2_DS, BB1_DS, BB3_DS, DOWNSTREAM_FUSE_BOX, COVER_FUSE_BOX, Fuse_METAL2_1
boundaries and excitations:
  BB2: SignalNet Objects=[BB2, STUD2_1, STUD2_2, BB2_DS, Fuse_METAL2_1]
  Sink2: Sink Faces=BB2.face(at (15, -3.5, 1.4), at (15, -6.5, 1.4)) TerminalType=ConstantVoltage Net=BB2
  Source2_1: Source Faces=BB2_DS.face(at (40.2, 262.3, 193), at (35.2, 262.3, 191), at (30.2, 262.3, 193), at (35.2, 262.3, 195)) TerminalType=ConstantVoltage Net=BB2
  Source2_2: Source Faces=BB2_DS.face(at (40.2, 262.3, 172), at (35.2, 262.3, 170), at (30.2, 262.3, 172), at (35.2, 262.3, 174)) TerminalType=ConstantVoltage Net=BB2
  Source2_3: Source Faces=BB2_DS.face(at (40.2, 262.3, 151), at (35.2, 262.3, 149), at (30.2, 262.3, 151), at (35.2, 262.3, 153)) TerminalType=ConstantVoltage Net=BB2
setups:
  Setup1: Matrix AdaptiveFreq=1kHz SaveFields DC{Cond{MaxPass=10 MinPass=1 MinConvPass=1 PerError=2 PerRefine=30} Mult{MaxPass=1 MinPass=1 MinConvPass=1 PerError=1 PerRefine=30} AccuracyLevel=Normal} ErrorValue=0.1
source amplitudes:
  BB2:Source2_1: AC R/L Fields 1A 0deg
  BB2:Source2_2, BB2:Source2_3: AC R/L Fields 0A 0deg
  BB2: CG Fields 1V 0deg
  BB2:Source2_1, BB2:Source2_2, BB2:Source2_3: DC R/L Fields I_DC 0deg
field plots:
  Volume_Loss_DensityDc1: Volume Loss Density over BB2, BB2_DS, Fuse_METAL2_1, STUD2_1, STUD2_2 on Setup1 : LastAdaptive at Freq=10e-07GHz Phase=0deg
