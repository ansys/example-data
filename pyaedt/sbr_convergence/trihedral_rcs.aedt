# Ansys Electronics Desktop project, version 2025.2
materials:
  vacuum: permittivity=1
  pec: conductivity=1e+30

design HFSSDesign1 (HFSS, SBR+, model units mm)
options: Allow_Material_Override
geometry:
  Polyline1 = imported_body(D:\ansysdev\PyAEDT\projects\trihedral.x_b)
  Polyline1.rotate(axis=Z, angle=-90deg)
boundaries and excitations:
  PerfE1: Perfect E Objects=Polyline1
  IncPWave1: Plane Incident Wave PhiStart=225deg PhiStop=315deg PhiPoints=181 ThetaStart=90deg ThetaStop=90deg ThetaPoints=1 EoPhi=0 EoTheta=-1 OriginX=0mm OriginY=-1meter OriginZ=0mm IsPropagating
mesh:
  initial mesh: GlobalSurfApproximation{CurvedSurfaceApproxChoice=UseSlider SliderMeshSettings=7}
setups:
  SBR: HfssDriven ComputeFields RayDensityPerWavelength=3 MaxNumberOfBounces=4 IsMonostaticRCS PTDUTDSimulationSettings=None CWRaySampleDensity=10 CWRayCutoffDb=40 CWCurvatureSensitivity=50 CWAngularRayInterval=2
    sweep Sweep: point 40GHz;
source amplitudes:
  IncPWave1:1: 1 0deg
