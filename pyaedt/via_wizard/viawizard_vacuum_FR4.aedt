# Ansys Electronics Desktop project, version 2025.1
materials:
  vacuum: permittivity=1
  WizardDie4.4_0.02: permittivity="4.11483 + 0.0281238*ln((2.53303e+022 + Freq*Freq)/(4.95658e+009 + Freq*Freq))" conductivity=1e-12+3.12919e-012*Freq*(atan(Freq/70403)-atan(Freq/1.59155e+011))
  copper: permeability=0.999991 conductivity=58000000
  air: permittivity=1.0006 permeability=1.0000004
  FR4_epoxy: permittivity=4.4 dielectric_loss_tangent=0.02

design HFSSDesign1 (HFSS, HFSS Hybrid Terminal Network, model units mil)
options: Allow_Material_Override Calculate_Lossy_Dielectrics Save_Adaptive_support_files
variables:
  L1_Cond_Thickness = 1.2mil
  L1_Die_Thickness = 5mil
  L1_Cond_Elevation = -1*L1_Cond_Thickness
  L1_Die_Elevation = -1*L1_Cond_Thickness - L1_Die_Thickness
  L2_Cond_Thickness = 1.2mil
  L2_Die_Thickness = 5mil
  L2_Cond_Elevation = L1_Die_Elevation - L2_Cond_Thickness
  L2_Die_Elevation = L2_Cond_Elevation - L2_Die_Thickness
  L3_Cond_Thickness = 1.2mil
  L3_Die_Thickness = 5mil
  L3_Cond_Elevation = L2_Die_Elevation - L3_Cond_Thickness
  L3_Die_Elevation = L3_Cond_Elevation - L3_Die_Thickness
  L4_Cond_Thickness = 1.2mil
  L4_Die_Thickness = 5mil
  L4_Cond_Elevation = L3_Die_Elevation - L4_Cond_Thickness
  L4_Die_Elevation = L4_Cond_Elevation - L4_Die_Thickness
  L5_Cond_Thickness = 1.2mil
  L5_Die_Thickness = 5mil
  L5_Cond_Elevation = L4_Die_Elevation - L5_Cond_Thickness
  L5_Die_Elevation = L5_Cond_Elevation - L5_Die_Thickness
  L6_Cond_Thickness = 1.2mil
  L6_Die_Thickness = 0mil
  L6_Cond_Elevation = L5_Die_Elevation - L6_Cond_Thickness
  L6_Die_Elevation = L6_Cond_Elevation - L6_Die_Thickness
  Xmin = -64mil
  Xlength = 128mil
  Ymin = -64mil
  Ylength = 157mil
  Zmin = L6_Die_Elevation - 6*L5_Die_Thickness
  Zlength = -1*Zmin + 6*L1_Die_Thickness
  Via1_x = 0mil
  Via1_y = 0mil
  Via1_antipad = 16mil
  Via1_Layer1_antipad = Via1_antipad
  Via1_Layer1_Antipad_x_offset = 0mil
  Via1_Layer1_Antipad_x_center = Via1_x+Via1_Layer1_Antipad_x_offset
  Via1_Layer1_Antipad_y_offset = 0mil
  Via1_Layer1_Antipad_y_center = Via1_y+Via1_Layer1_Antipad_y_offset
  Via1_Layer2_antipad = Via1_antipad
  Via1_Layer2_Antipad_x_offset = 0mil
  Via1_Layer2_Antipad_x_center = Via1_x+Via1_Layer2_Antipad_x_offset
  Via1_Layer2_Antipad_y_offset = 0mil
  Via1_Layer2_Antipad_y_center = Via1_y+Via1_Layer2_Antipad_y_offset
  Via1_Layer4_antipad = Via1_antipad
  Via1_Layer4_Antipad_x_offset = 0mil
  Via1_Layer4_Antipad_x_center = Via1_x+Via1_Layer4_Antipad_x_offset
  Via1_Layer4_Antipad_y_offset = 0mil
  Via1_Layer4_Antipad_y_center = Via1_y+Via1_Layer4_Antipad_y_offset
  Via1_Layer5_antipad = Via1_antipad
  Via1_Layer5_Antipad_x_offset = 0mil
  Via1_Layer5_Antipad_x_center = Via1_x+Via1_Layer5_Antipad_x_offset
  Via1_Layer5_Antipad_y_offset = 0mil
  Via1_Layer5_Antipad_y_center = Via1_y+Via1_Layer5_Antipad_y_offset
  Via1_Layer6_antipad = Via1_antipad
  Via1_Layer6_Antipad_x_offset = 0mil
  Via1_Layer6_Antipad_x_center = Via1_x+Via1_Layer6_Antipad_x_offset
  Via1_Layer6_Antipad_y_offset = 0mil
  Via1_Layer6_Antipad_y_center = Via1_y+Via1_Layer6_Antipad_y_offset
  Via1_trace_in_bot = 5mil
  Via1_trace_in_top = Via1_trace_in_bot - 0*L1_Cond_Thickness
  Via1_trace_out_top = 5mil
  Via1_trace_out_bot = Via1_trace_out_top - 0*L5_Cond_Thickness
  Via2_x = 0mil
  Via2_y = 29mil
  Via2_antipad = 16mil
  Via2_Layer1_antipad = Via2_antipad
  Via2_Layer1_Antipad_x_offset = 0mil
  Via2_Layer1_Antipad_x_center = Via2_x+Via2_Layer1_Antipad_x_offset
  Via2_Layer1_Antipad_y_offset = 0mil
  Via2_Layer1_Antipad_y_center = Via2_y+Via2_Layer1_Antipad_y_offset
  Via2_Layer2_antipad = Via2_antipad
  Via2_Layer2_Antipad_x_offset = 0mil
  Via2_Layer2_Antipad_x_center = Via2_x+Via2_Layer2_Antipad_x_offset
  Via2_Layer2_Antipad_y_offset = 0mil
  Via2_Layer2_Antipad_y_center = Via2_y+Via2_Layer2_Antipad_y_offset
  Via2_Layer4_antipad = Via2_antipad
  Via2_Layer4_Antipad_x_offset = 0mil
  Via2_Layer4_Antipad_x_center = Via2_x+Via2_Layer4_Antipad_x_offset
  Via2_Layer4_Antipad_y_offset = 0mil
  Via2_Layer4_Antipad_y_center = Via2_y+Via2_Layer4_Antipad_y_offset
  Via2_Layer5_antipad = Via2_antipad
  Via2_Layer5_Antipad_x_offset = 0mil
  Via2_Layer5_Antipad_x_center = Via2_x+Via2_Layer5_Antipad_x_offset
  Via2_Layer5_Antipad_y_offset = 0mil
  Via2_Layer5_Antipad_y_center = Via2_y+Via2_Layer5_Antipad_y_offset
  Via2_Layer6_antipad = Via2_antipad
  Via2_Layer6_Antipad_x_offset = 0mil
  Via2_Layer6_Antipad_x_center = Via2_x+Via2_Layer6_Antipad_x_offset
  Via2_Layer6_Antipad_y_offset = 0mil
  Via2_Layer6_Antipad_y_center = Via2_y+Via2_Layer6_Antipad_y_offset
  Via2_trace_in_bot = 5mil
  Via2_trace_in_top = Via2_trace_in_bot - 0*L1_Cond_Thickness
  Via2_trace_out_top = 5mil
  Via2_trace_out_bot = Via2_trace_out_top - 0*L5_Cond_Thickness
  Via1_in1_x = Via1_x + 8mil
  Via1_in1_y = Via1_y - .5*Via1_trace_in_bot
  Via1_in2_x = (Via1_in1_x + Xmin + Xlength)/2
  Via1_in2_y = Via1_in1_y
  Via1_in3_x = Xmin + Xlength
  Via1_in3_y = Via1_in2_y
  Via2_in1_x = Via2_x + 8mil
  Via2_in1_y = Via2_y - .5*Via2_trace_in_bot
  Via2_in2_x = (Via2_in1_x + Xmin + Xlength)/2
  Via2_in2_y = Via2_in1_y
  Via2_in3_x = Xmin + Xlength
  Via2_in3_y = Via2_in2_y
  Via1_out1_x = Via1_x - 8mil
  Via1_out1_y = Via1_y - .5*Via1_trace_out_top
  Via1_out2_x = (Via1_out1_x + Xmin)/2
  Via1_out2_y = Via1_out1_y
  Via1_out3_x = Xmin
  Via1_out3_y = Via1_out2_y
  Via2_out1_x = Via2_x - 8mil
  Via2_out1_y = Via2_y - .5*Via2_trace_out_top
  Via2_out2_x = (Via2_out1_x + Xmin)/2
  Via2_out2_y = Via2_out1_y
  Via2_out3_x = Xmin
  Via2_out3_y = Via2_out2_y
  Port1_in_left_wall = if(Via1_in3_y - 5*Via1_trace_in_bot < Ymin , Ymin, Via1_in3_y - 5*Via1_trace_in_bot)
  Port1_in_right_wall = if(Via2_in3_y + 5*Via2_trace_in_bot > Ymin + Ylength , Ymin + Ylength, Via2_in3_y + 5*Via2_trace_in_bot)
  Port5_out_left_wall = if(Via1_out3_y - 5*Via1_trace_out_top < Ymin , Ymin, Via1_out3_y - 5*Via1_trace_out_top)
  Port5_out_right_wall = if(Via2_out3_y + 5*Via2_trace_out_top > Ymin + Ylength , Ymin + Ylength, Via2_out3_y + 5*Via2_trace_out_top)
geometry:
  1_pd [FR4_epoxy] = box(corner=(Xmin, Ymin, L1_Die_Elevation), size=(Xlength, Ylength, L1_Die_Thickness))
  2_pc [copper] = box(corner=(Xmin, Ymin, L2_Cond_Elevation), size=(Xlength, Ylength, L2_Cond_Thickness))
  2_pd [FR4_epoxy] = box(corner=(Xmin, Ymin, L2_Die_Elevation), size=(Xlength, Ylength, L2_Die_Thickness))
  3_pd [FR4_epoxy] = box(corner=(Xmin, Ymin, L3_Die_Elevation), size=(Xlength, Ylength, L3_Die_Thickness + L3_Cond_Thickness))
  4_pc [copper] = box(corner=(Xmin, Ymin, L4_Cond_Elevation), size=(Xlength, Ylength, L4_Cond_Thickness))
  4_pd [FR4_epoxy] = box(corner=(Xmin, Ymin, L4_Die_Elevation), size=(Xlength, Ylength, L4_Die_Thickness))
  5_pd [FR4_epoxy] = box(corner=(Xmin, Ymin, L5_Die_Elevation), size=(Xlength, Ylength, L5_Die_Thickness + L5_Cond_Thickness))
  6_pc [copper] = box(corner=(Xmin, Ymin, L6_Cond_Elevation), size=(Xlength, Ylength, L6_Cond_Thickness))
  AirBox [vacuum] = box(corner=(Xmin, Ymin, Zmin), size=(Xlength, Ylength, Zlength))
  1_1_p = cylinder(axis=Z, base_centre=(Via1_x, Via1_y, L1_Cond_Elevation), radius=12mil, height=L1_Cond_Thickness)
  1_2_ap = cylinder(axis=Z, base_centre=(Via1_Layer2_Antipad_x_center, Via1_Layer2_Antipad_y_center, L2_Cond_Elevation), radius=Via1_Layer2_antipad, height=L2_Cond_Thickness)
  1_2_ap_1 = 1_2_ap.copy()
  2_pc.subtract(1_2_ap_1)
  2_pd.unite(1_2_ap)
  1_2_p = cylinder(axis=Z, base_centre=(Via1_x, Via1_y, L2_Cond_Elevation), radius=8mil, height=L2_Cond_Thickness)
  2_pd.subtract(1_2_p)
  1_3_p = cylinder(axis=Z, base_centre=(Via1_x, Via1_y, L3_Cond_Elevation), radius=8mil, height=L3_Cond_Thickness)
  1_4_ap = cylinder(axis=Z, base_centre=(Via1_Layer4_Antipad_x_center, Via1_Layer4_Antipad_y_center, L4_Cond_Elevation), radius=Via1_Layer4_antipad, height=L4_Cond_Thickness)
  1_4_ap_1 = 1_4_ap.copy()
  4_pc.subtract(1_4_ap_1)
  4_pd.unite(1_4_ap)
  1_4_p = cylinder(axis=Z, base_centre=(Via1_x, Via1_y, L4_Cond_Elevation), radius=12mil, height=L4_Cond_Thickness)
  1_4_p_1 = 1_4_p.copy()
  4_pd.subtract(1_4_p_1)
  1_5_p = cylinder(axis=Z, base_centre=(Via1_x, Via1_y, L5_Cond_Elevation), radius=12mil, height=L5_Cond_Thickness)
  1_6_ap = cylinder(axis=Z, base_centre=(Via1_Layer6_Antipad_x_center, Via1_Layer6_Antipad_y_center, L6_Cond_Elevation), radius=Via1_Layer6_antipad, height=L6_Cond_Thickness)
  1_6_ap_1 = 1_6_ap.copy()
  6_pc.subtract(1_6_ap_1)
  5_pd.unite(1_6_ap)
  1_6_p = cylinder(axis=Z, base_centre=(Via1_x, Via1_y, L6_Cond_Elevation), radius=12mil, height=L6_Cond_Thickness)
  Via1 [copper] = cylinder(axis=Z, base_centre=(Via1_x, Via1_y, L6_Cond_Elevation), radius=8mil, height=L1_Cond_Elevation - L6_Cond_Elevation + L1_Cond_Thickness)
  Via1_drill [vacuum] = cylinder(axis=Z, base_centre=(Via1_x, Via1_y, L6_Cond_Elevation), radius=6.4mil, height=L1_Cond_Elevation - L6_Cond_Elevation + L1_Cond_Thickness)
  Via1.unite(1_1_p)
  Via1.unite(1_3_p)
  Via1.unite(1_4_p)
  Via1.unite(1_5_p)
  Via1.unite(1_6_p)
  Via1_1 = Via1.copy()
  1_pd.subtract(Via1_1)
  Via1_2 = Via1.copy()
  2_pd.subtract(Via1_2)
  Via1_3 = Via1.copy()
  3_pd.subtract(Via1_3)
  Via1_4 = Via1.copy()
  4_pd.subtract(Via1_4)
  Via1_5 = Via1.copy()
  5_pd.subtract(Via1_5)
  Via1_drill_1 = Via1_drill.copy()
  Via1.subtract(Via1_drill_1)
  2_1_p = cylinder(axis=Z, base_centre=(Via2_x, Via2_y, L1_Cond_Elevation), radius=12mil, height=L1_Cond_Thickness)
  2_2_ap = cylinder(axis=Z, base_centre=(Via2_Layer2_Antipad_x_center, Via2_Layer2_Antipad_y_center, L2_Cond_Elevation), radius=Via2_Layer2_antipad, height=L2_Cond_Thickness)
  2_2_ap_1 = 2_2_ap.copy()
  2_pc.subtract(2_2_ap_1)
  2_pd.unite(2_2_ap)
  2_2_p = cylinder(axis=Z, base_centre=(Via2_x, Via2_y, L2_Cond_Elevation), radius=8mil, height=L2_Cond_Thickness)
  2_pd.subtract(2_2_p)
  2_3_p = cylinder(axis=Z, base_centre=(Via2_x, Via2_y, L3_Cond_Elevation), radius=8mil, height=L3_Cond_Thickness)
  2_4_ap = cylinder(axis=Z, base_centre=(Via2_Layer4_Antipad_x_center, Via2_Layer4_Antipad_y_center, L4_Cond_Elevation), radius=Via2_Layer4_antipad, height=L4_Cond_Thickness)
  2_4_ap_1 = 2_4_ap.copy()
  4_pc.subtract(2_4_ap_1)
  4_pd.unite(2_4_ap)
  2_4_p = cylinder(axis=Z, base_centre=(Via2_x, Via2_y, L4_Cond_Elevation), radius=12mil, height=L4_Cond_Thickness)
  2_4_p_1 = 2_4_p.copy()
  4_pd.subtract(2_4_p_1)
  2_5_p = cylinder(axis=Z, base_centre=(Via2_x, Via2_y, L5_Cond_Elevation), radius=12mil, height=L5_Cond_Thickness)
  2_6_ap = cylinder(axis=Z, base_centre=(Via2_Layer6_Antipad_x_center, Via2_Layer6_Antipad_y_center, L6_Cond_Elevation), radius=Via2_Layer6_antipad, height=L6_Cond_Thickness)
  2_6_ap_1 = 2_6_ap.copy()
  6_pc.subtract(2_6_ap_1)
  5_pd.unite(2_6_ap)
  2_6_p = cylinder(axis=Z, base_centre=(Via2_x, Via2_y, L6_Cond_Elevation), radius=12mil, height=L6_Cond_Thickness)
  Via2 [copper] = cylinder(axis=Z, base_centre=(Via2_x, Via2_y, L6_Cond_Elevation), radius=8mil, height=L1_Cond_Elevation - L6_Cond_Elevation + L1_Cond_Thickness)
  Via2_drill [vacuum] = cylinder(axis=Z, base_centre=(Via2_x, Via2_y, L6_Cond_Elevation), radius=6.4mil, height=L1_Cond_Elevation - L6_Cond_Elevation + L1_Cond_Thickness)
  Via2.unite(2_1_p)
  Via2.unite(2_3_p)
  Via2.unite(2_4_p)
  Via2.unite(2_5_p)
  Via2.unite(2_6_p)
  Via2_1 = Via2.copy()
  1_pd.subtract(Via2_1)
  Via2_2 = Via2.copy()
  2_pd.subtract(Via2_2)
  Via2_3 = Via2.copy()
  3_pd.subtract(Via2_3)
  Via2_4 = Via2.copy()
  4_pd.subtract(Via2_4)
  Via2_5 = Via2.copy()
  5_pd.subtract(Via2_5)
  Via2_drill_1 = Via2_drill.copy()
  Via2.subtract(Via2_drill_1)
  1_trace_in = polyline(x=Xmin + Xlength, yz: (Via1_in3_y, L1_Cond_Elevation) (Via1_in3_y + Via1_trace_in_bot, L1_Cond_Elevation) (Via1_in3_y + .5*Via1_trace_in_bot + .5*Via1_trace_in_top, L1_Cond_Elevation + L1_Cond_Thickness) (Via1_in3_y + .5*Via1_trace_in_bot - .5*Via1_trace_in_top, L1_Cond_Elevation + L1_Cond_Thickness) (Via1_in3_y, L1_Cond_Elevation), closed, covered)
  1_path_in = polyline(z=L1_Cond_Elevation, xy: (Via1_in1_x, Via1_in1_y) (Via1_in2_x, Via1_in2_y) (Via1_in3_x, Via1_in3_y))
  1_trace_in.sweep_along_path(1_path_in)
  Via1.unite(1_trace_in)
  Via1_drill_2 = Via1_drill.copy()
  Via1.subtract(Via1_drill_2)
  2_trace_in = polyline(x=Xmin + Xlength, yz: (Via2_in3_y, L1_Cond_Elevation) (Via2_in3_y + Via2_trace_in_bot, L1_Cond_Elevation) (Via2_in3_y + .5*Via2_trace_in_bot + .5*Via2_trace_in_top, L1_Cond_Elevation + L1_Cond_Thickness) (Via2_in3_y + .5*Via2_trace_in_bot - .5*Via2_trace_in_top, L1_Cond_Elevation + L1_Cond_Thickness) (Via2_in3_y, L1_Cond_Elevation), closed, covered)
  2_path_in = polyline(z=L1_Cond_Elevation, xy: (Via2_in1_x, Via2_in1_y) (Via2_in2_x, Via2_in2_y) (Via2_in3_x, Via2_in3_y))
  2_trace_in.sweep_along_path(2_path_in)
  Via2.unite(2_trace_in)
  Via2_drill_2 = Via2_drill.copy()
  Via2.subtract(Via2_drill_2)
  1_trace_out = polyline(x=Xmin, yz: (Via1_out3_y, L5_Cond_Elevation) (Via1_out3_y + Via1_trace_out_bot, L5_Cond_Elevation) (Via1_out3_y + .5*Via1_trace_out_bot + .5*Via1_trace_out_top, L5_Cond_Elevation + L5_Cond_Thickness) (Via1_out3_y + .5*Via1_trace_out_bot - .5*Via1_trace_out_top, L5_Cond_Elevation + L5_Cond_Thickness) (Via1_out3_y, L5_Cond_Elevation), closed, covered)
  1_path_out = polyline(z=L5_Cond_Elevation, xy: (Via1_out1_x, Via1_out1_y) (Via1_out2_x, Via1_out2_y) (Via1_out3_x, Via1_out3_y))
  1_trace_out.sweep_along_path(1_path_out)
  Via1.unite(1_trace_out)
  Via1_drill_3 = Via1_drill.copy()
  Via1.subtract(Via1_drill_3)
  2_trace_out = polyline(x=Xmin, yz: (Via2_out3_y, L5_Cond_Elevation) (Via2_out3_y + Via2_trace_out_bot, L5_Cond_Elevation) (Via2_out3_y + .5*Via2_trace_out_bot + .5*Via2_trace_out_top, L5_Cond_Elevation + L5_Cond_Thickness) (Via2_out3_y + .5*Via2_trace_out_bot - .5*Via2_trace_out_top, L5_Cond_Elevation + L5_Cond_Thickness) (Via2_out3_y, L5_Cond_Elevation), closed, covered)
  2_path_out = polyline(z=L5_Cond_Elevation, xy: (Via2_out1_x, Via2_out1_y) (Via2_out2_x, Via2_out2_y) (Via2_out3_x, Via2_out3_y))
  2_trace_out.sweep_along_path(2_path_out)
  Via2.unite(2_trace_out)
  Via2_drill_3 = Via2_drill.copy()
  Via2.subtract(Via2_drill_3)
  Port1_in = rectangle(corner=(Xmin + Xlength, Port1_in_left_wall, L1_Die_Elevation), y_size=Port1_in_right_wall- Port1_in_left_wall, z_size=Zmin + Zlength - L1_Die_Elevation)
  Port5_out = rectangle(corner=(Xmin, Port5_out_left_wall, L5_Die_Elevation), y_size=Port5_out_right_wall- Port5_out_left_wall, z_size=L4_Cond_Elevation - L5_Die_Elevation)
boundaries and excitations:
  Rad1: Radiation Objects=AirBox
  WavePortIN1_T1: Terminal port=WavePortIN1 Faces=Via1.face(at (64, 0, -0.6)) TerminalResistance=50ohm
  WavePortIN1_T2: Terminal port=WavePortIN1 Faces=Via2.face(at (64, 29, -0.6)) TerminalResistance=50ohm
  WavePortOUT5_T1: Terminal port=WavePortOUT5 Faces=Via1.face(at (-64, 0, -25.4)) TerminalResistance=50ohm
  WavePortOUT5_T2: Terminal port=WavePortOUT5 Faces=Via2.face(at (-64, 29, -25.4)) TerminalResistance=50ohm
  WavePortIN1: Wave Port Objects=Port1_in WavePortType=Terminal NumModes=2 DeembedDist=48mil
  WavePortOUT5: Wave Port Objects=Port5_out WavePortType=Terminal NumModes=2 DeembedDist=48mil
setups:
  WizardSetup: HfssDriven Frequency=4380MHz MaxDeltaS=0.02 MaximumPasses=12 MinimumPasses=1 MinimumConvergedPasses=1 PercentRefinement=30 BasisOrder=-1 PortAccuracy=0.1 PortMinTri=500 PortMaxTri=5000 DrivenSolverType="Direct Solver" IESolverType=ACA
    sweep WizardSweep: 0MHz to 4380MHz step 50MHz; Type=Interpolating InterpTolerance=0.1 InterpMaxSolns=50 MinSolvedFreq=0.2GHz InterpUsePortImped=false InterpUsePropConst=false
source amplitudes:
  WavePortIN1:1: 1 0deg
  WavePortIN1:2, WavePortOUT5:1, WavePortOUT5:2: 0 0deg
reports:
  XY Plot 1: dB(St(WavePortIN1_T1,WavePortIN1_T1)), dB(St(WavePortIN1_T1,WavePortIN1_T2)), dB(St(WavePortIN1_T1,WavePortOUT5_T1)), dB(St(WavePortIN1_T1,WavePortOUT5_T2)) vs Freq on WizardSetup : WizardSweep
