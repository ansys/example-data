# Ansys Electronics Desktop project, version 2022.2
materials:
  M19_24G: permeability{HUnit=A_per_meter BUnit=tesla curve (0, 0) (22.28, 0.05) (25.46, 0.1) (31.83, 0.15) (47.74, 0.36) (63.66, 0.54) (79.57, 0.65) (159.15, 0.99) (318.3, 1.2) (477.46, 1.28) (636.61, 1.33) (795.77, 1.36) (1591.5, 1.44) (3183, 1.52) (4774.6, 1.58) (6366.1, 1.63) (7957.7, 1.67) (15915, 1.8) (31830, 1.9) (111407, 2) (190984, 2.1) (350138, 2.3) (509292, 2.5)} conductivity=1960000 core_loss_type="Electrical Steel" core_loss_kh=164.2 core_loss_kc=1.3 core_loss_ke=1.72 mass_density=7650
  steel_1008: permeability{HUnit=A_per_meter BUnit=tesla curve (0, 0) (159.2, 0.2402) (318.3, 0.8654) (477.5, 1.1106) (636.6, 1.2458) (795.8, 1.331) (1591.5, 1.5) (3183.1, 1.6) (4774.6, 1.683) (6366.2, 1.741) (7957.7, 1.78) (15915.5, 1.905) (31831, 2.025) (47746.5, 2.085) (63662, 2.13) (79577.5, 2.165) (159155, 2.28) (318310, 2.485) (397887, 2.5851)} conductivity=2000000
  copper_75C: permeability=0.999991 conductivity=46000000
  vacuum: permittivity=1
  M19_24G_2DSF0.811: permeability{HUnit=A_per_meter BUnit=tesla curve (0, 0) (22.28, 0.0405432) (25.46, 0.0810819) (31.83, 0.121621) (47.74, 0.291884) (63.66, 0.437824) (79.57, 0.527012) (159.15, 0.802688) (318.3, 0.972985) (477.46, 1.03788) (636.61, 1.07846) (795.77, 1.10282) (1591.5, 1.16787) (3183, 1.23311) (4774.6, 1.28213) (6366.1, 1.32305) (7957.7, 1.35586) (15915, 1.46315) (31830, 1.54801) (111407, 1.64801) (190984, 1.74801) (350138, 1.94801) (509292, 2.14801) (2100830, 4.14801)} conductivity=1960000 core_loss_type="Electrical Steel" core_loss_kh=202.527 core_loss_kc=1.60344 core_loss_ke=1.91022 mass_density=6202.3
  steel_1008_2DSF1.011: permeability{HUnit=A_per_meter BUnit=tesla curve (0, 0) (159.2, 0.242756) (318.3, 0.874611) (477.5, 1.12242) (636.6, 1.25906) (795.8, 1.34516) (1591.5, 1.51595) (3183.1, 1.617) (4774.6, 1.70086) (6366.2, 1.75945) (7957.7, 1.79885) (15915.5, 1.92507) (31831, 2.04614) (47746.5, 2.10656) (63662, 2.15183) (79577.5, 2.18699) (159155, 2.30215) (318310, 2.5072) (397887, 2.6073) (1193660, 3.60832)} conductivity=2000000
  copper: permeability=0.999991 conductivity=58000000

design 01_currentDriven (Maxwell 2D, Transient, XY geometry, model units mm)
options: ComputeTransientInductance ModelDepth=375.204mm
variables:
  fractions = 6
  delta = 35.499302deg
  conds = 5
  R1 = 0.0071935147ohm
  Le1 = 3.7420545e-05H
geometry:
  Band [vacuum] = user_primitive(RMxprt/Band, DiaGap=555.25mm, DiaYoke=160mm, Length=0mm, SegAngle=0deg, Fractions=1, HalfAxial=0, InfoCore=0)
  Shaft [vacuum] = user_primitive(RMxprt/Band, DiaGap=555.25mm, DiaYoke=160mm, Length=0mm, SegAngle=0deg, Fractions=1, HalfAxial=0, InfoCore=100)
  OuterRegion [vacuum] = user_primitive(RMxprt/Band, DiaGap=555.25mm, DiaYoke=736.6mm, Length=0mm, SegAngle=0deg, Fractions=fractions, HalfAxial=0, InfoCore=100)
  Tool = user_primitive(RMxprt/Band, DiaGap=555.25mm, DiaYoke=736.6mm, Length=0mm, SegAngle=0deg, Fractions=fractions, HalfAxial=0, InfoCore=1)
  Stator [M19_24G_2DSF0.811] = user_primitive(RMxprt/SlotCore, DiaGap=558.8mm, DiaYoke=736.6mm, Length=0mm, Skew=0deg, Slots=72, SlotType=3, Hs0=0.76mm, Hs01=0mm, Hs1=2.17mm, Hs2=29.4mm, Bs0=3.9mm, Bs1=11.4mm, Bs2=15mm, Rs=0mm, FilletType=0, HalfSlot=0, SegAngle=15deg, LenRegion=0mm, InfoCore=0)
  Coil_0 [copper] = user_primitive(RMxprt/LapCoil, DiaGap=558.8mm, DiaYoke=736.6mm, Length=0mm, Skew=0deg, Slots=72, SlotType=3, Hs0=0.76mm, Hs1=2.17mm, Hs2=29.4mm, Bs0=3.9mm, Bs1=11.4mm, Bs2=15mm, Rs=0mm, FilletType=0, Layers=2, CoilPitch=11, EndExt=47.5mm, SpanExt=0mm, BendAngle=0deg, SegAngle=10deg, LenRegion=0mm, InfoCoil=2)
  Coil_1..Coil_11 [copper], Coil_12..Coil_71 = Coil_0.duplicate_around_axis(axis=Z, angle=5deg, total=72)
  Coil_0.unite(Coil_12, Coil_24, Coil_36, Coil_48, Coil_60)
  Coil_1.unite(Coil_13, Coil_25, Coil_37, Coil_49, Coil_61)
  Coil_2.unite(Coil_14, Coil_26, Coil_38, Coil_50, Coil_62)
  Coil_3.unite(Coil_15, Coil_27, Coil_39, Coil_51, Coil_63)
  Coil_4.unite(Coil_16, Coil_28, Coil_40, Coil_52, Coil_64)
  Coil_5.unite(Coil_17, Coil_29, Coil_41, Coil_53, Coil_65)
  Coil_6.unite(Coil_18, Coil_30, Coil_42, Coil_54, Coil_66)
  Coil_7.unite(Coil_19, Coil_31, Coil_43, Coil_55, Coil_67)
  Coil_8.unite(Coil_20, Coil_32, Coil_44, Coil_56, Coil_68)
  Coil_9.unite(Coil_21, Coil_33, Coil_45, Coil_57, Coil_69)
  Coil_10.unite(Coil_22, Coil_34, Coil_46, Coil_58, Coil_70)
  Coil_11.unite(Coil_23, Coil_35, Coil_47, Coil_59, Coil_71)
  CoilRe_0 [copper] = user_primitive(RMxprt/LapCoil, DiaGap=558.8mm, DiaYoke=736.6mm, Length=0mm, Skew=0deg, Slots=72, SlotType=3, Hs0=0.76mm, Hs1=2.17mm, Hs2=29.4mm, Bs0=3.9mm, Bs1=11.4mm, Bs2=15mm, Rs=0mm, FilletType=0, Layers=2, CoilPitch=11, EndExt=47.5mm, SpanExt=0mm, BendAngle=0deg, SegAngle=10deg, LenRegion=0mm, InfoCoil=3)
  CoilRe_0.rotate(axis=Z, angle=-55deg)
  CoilRe_1..CoilRe_11 [copper], CoilRe_12..CoilRe_71 = CoilRe_0.duplicate_around_axis(axis=Z, angle=5deg, total=72)
  CoilRe_0.unite(CoilRe_12, CoilRe_24, CoilRe_36, CoilRe_48, CoilRe_60)
  CoilRe_1.unite(CoilRe_13, CoilRe_25, CoilRe_37, CoilRe_49, CoilRe_61)
  CoilRe_2.unite(CoilRe_14, CoilRe_26, CoilRe_38, CoilRe_50, CoilRe_62)
  CoilRe_3.unite(CoilRe_15, CoilRe_27, CoilRe_39, CoilRe_51, CoilRe_63)
  CoilRe_4.unite(CoilRe_16, CoilRe_28, CoilRe_40, CoilRe_52, CoilRe_64)
  CoilRe_5.unite(CoilRe_17, CoilRe_29, CoilRe_41, CoilRe_53, CoilRe_65)
  CoilRe_6.unite(CoilRe_18, CoilRe_30, CoilRe_42, CoilRe_54, CoilRe_66)
  CoilRe_7.unite(CoilRe_19, CoilRe_31, CoilRe_43, CoilRe_55, CoilRe_67)
  CoilRe_8.unite(CoilRe_20, CoilRe_32, CoilRe_44, CoilRe_56, CoilRe_68)
  CoilRe_9.unite(CoilRe_21, CoilRe_33, CoilRe_45, CoilRe_57, CoilRe_69)
  CoilRe_10.unite(CoilRe_22, CoilRe_34, CoilRe_46, CoilRe_58, CoilRe_70)
  CoilRe_11.unite(CoilRe_23, CoilRe_35, CoilRe_47, CoilRe_59, CoilRe_71)
  Rotor [steel_1008_2DSF1.011] = user_primitive(RMxprt/SalientPoleCore, DiaGap=551.7mm, DiaYoke=160mm, Length=0mm, Skew=0deg, Slots=0, SlotType=0, Hs0=0mm, Hs01=0mm, Hs1=0mm, Hs2=0mm, Bs0=0mm, Bs1=0mm, Bs2=0mm, Rs=0mm, FilletType=0, SlotPitch=0deg, CenterPitch=0deg, Poles=6, PoleType=1, WidthShoe=189.5mm, HeightShoe=36.6mm, WidthBody=99.1mm, HeightBody=110mm, AirGap2=0mm, Offset=25.85mm, Off2_x=0mm, Off2_y=0mm, Bp1/Rp1=0mm, Bp2/Rp2=0mm, CoilEndExt=2mm, EndRingType=0, BarEndExt=0mm, RingLength=0mm, RingHeight=0mm, SegAngle=15deg, LenRegion=0mm, InfoCore=0)
  Field_0 [copper] = user_primitive(RMxprt/SalientPoleCore, DiaGap=551.7mm, DiaYoke=160mm, Length=0mm, Skew=0deg, Slots=0, SlotType=0, Hs0=0mm, Hs01=0mm, Hs1=0mm, Hs2=0mm, Bs0=0mm, Bs1=0mm, Bs2=0mm, Rs=0mm, FilletType=0, SlotPitch=0deg, CenterPitch=0deg, Poles=6, PoleType=1, WidthShoe=189.5mm, HeightShoe=36.6mm, WidthBody=99.1mm, HeightBody=110mm, AirGap2=0mm, Offset=25.85mm, Off2_x=0mm, Off2_y=0mm, Bp1/Rp1=0mm, Bp2/Rp2=0mm, CoilEndExt=2mm, EndRingType=0, BarEndExt=0mm, RingLength=0mm, RingHeight=0mm, SegAngle=15deg, LenRegion=0mm, InfoCore=4)
  Field_1..Field_5 = Field_0.duplicate_around_axis(axis=Z, angle=60deg, total=6)
  Field_0.unite(Field_1..Field_5)
  FieldRe_0 [copper] = user_primitive(RMxprt/SalientPoleCore, DiaGap=551.7mm, DiaYoke=160mm, Length=0mm, Skew=0deg, Slots=0, SlotType=0, Hs0=0mm, Hs01=0mm, Hs1=0mm, Hs2=0mm, Bs0=0mm, Bs1=0mm, Bs2=0mm, Rs=0mm, FilletType=0, SlotPitch=0deg, CenterPitch=0deg, Poles=6, PoleType=1, WidthShoe=189.5mm, HeightShoe=36.6mm, WidthBody=99.1mm, HeightBody=110mm, AirGap2=0mm, Offset=25.85mm, Off2_x=0mm, Off2_y=0mm, Bp1/Rp1=0mm, Bp2/Rp2=0mm, CoilEndExt=2mm, EndRingType=0, BarEndExt=0mm, RingLength=0mm, RingHeight=0mm, SegAngle=15deg, LenRegion=0mm, InfoCore=5)
  FieldRe_1..FieldRe_5 = FieldRe_0.duplicate_around_axis(axis=Z, angle=60deg, total=6)
  FieldRe_0.unite(FieldRe_1..FieldRe_5)
  InnerRegion [vacuum] = user_primitive(RMxprt/SalientPoleCore, DiaGap=551.7mm, DiaYoke=160mm, Length=0mm, Skew=0deg, Slots=0, SlotType=0, Hs0=0mm, Hs01=0mm, Hs1=0mm, Hs2=0mm, Bs0=0mm, Bs1=0mm, Bs2=0mm, Rs=0mm, FilletType=0, SlotPitch=0deg, CenterPitch=0deg, Poles=6, PoleType=1, WidthShoe=189.5mm, HeightShoe=36.6mm, WidthBody=99.1mm, HeightBody=110mm, AirGap2=0mm, Offset=25.85mm, Off2_x=0mm, Off2_y=0mm, Bp1/Rp1=0mm, Bp2/Rp2=0mm, CoilEndExt=2mm, EndRingType=0, BarEndExt=0mm, RingLength=0mm, RingHeight=0mm, SegAngle=15deg, LenRegion=0mm, InfoCore=100)
  Tool_1 = Tool.copy()
  Band.subtract(Tool_1)
  Tool_2 = Tool.copy()
  InnerRegion.subtract(Tool_2)
  Tool_3 = Tool.copy()
  Shaft.subtract(Tool_3)
  Tool_4 = Tool.copy()
  Stator.subtract(Tool_4)
  Tool_5 = Tool.copy()
  Coil_0.subtract(Tool_5)
  Tool_6 = Tool.copy()
  Coil_1.subtract(Tool_6)
  Tool_7 = Tool.copy()
  Coil_2.subtract(Tool_7)
  Tool_8 = Tool.copy()
  Coil_3.subtract(Tool_8)
  Tool_9 = Tool.copy()
  Coil_4.subtract(Tool_9)
  Tool_10 = Tool.copy()
  Coil_5.subtract(Tool_10)
  Tool_11 = Tool.copy()
  Coil_6.subtract(Tool_11)
  Tool_12 = Tool.copy()
  Coil_7.subtract(Tool_12)
  Tool_13 = Tool.copy()
  Coil_8.subtract(Tool_13)
  Tool_14 = Tool.copy()
  Coil_9.subtract(Tool_14)
  Tool_15 = Tool.copy()
  Coil_10.subtract(Tool_15)
  Tool_16 = Tool.copy()
  Coil_11.subtract(Tool_16)
  Tool_17 = Tool.copy()
  CoilRe_0.subtract(Tool_17)
  Tool_18 = Tool.copy()
  CoilRe_1.subtract(Tool_18)
  Tool_19 = Tool.copy()
  CoilRe_2.subtract(Tool_19)
  Tool_20 = Tool.copy()
  CoilRe_3.subtract(Tool_20)
  Tool_21 = Tool.copy()
  CoilRe_4.subtract(Tool_21)
  Tool_22 = Tool.copy()
  CoilRe_5.subtract(Tool_22)
  Tool_23 = Tool.copy()
  CoilRe_6.subtract(Tool_23)
  Tool_24 = Tool.copy()
  CoilRe_7.subtract(Tool_24)
  Tool_25 = Tool.copy()
  CoilRe_8.subtract(Tool_25)
  Tool_26 = Tool.copy()
  CoilRe_9.subtract(Tool_26)
  Tool_27 = Tool.copy()
  CoilRe_10.subtract(Tool_27)
  Tool_28 = Tool.copy()
  CoilRe_11.subtract(Tool_28)
  Tool_29 = Tool.copy()
  Rotor.subtract(Tool_29)
  Tool_30 = Tool.copy()
  Field_0.subtract(Tool_30)
  FieldRe_0.subtract(Tool)
motion:
  MotionSetup1: Band Move_Type=Rotate Coordinate_System=Global Axis=Z Is_Positive=true InitPos=67.5deg Angular_Velocity=1000rpm Objects=Band
  Moving1: Moving Objects=[Shaft, Rotor, Field_0, FieldRe_0, InnerRegion]
boundaries and excitations:
  VectorPotential1: Vector Potential Edges=OuterRegion.edge(at (318.957, 184.15, 0)) Value=0
  Independent1: Independent Edges=OuterRegion.edge(at (184.15, 0, 0))
  Dependent1: Dependent Edges=OuterRegion.edge(at (92.075, 159.479, 0)) ReverseU Independent=Independent1 SameAsMaster=false
  PhA_0: Coil Objects=Coil_0 Conductor_number=conds Winding=PhaseA PolarityType=Positive
  PhARe_0: Coil Objects=CoilRe_11 Conductor_number=conds Winding=PhaseA PolarityType=Negative
  PhA_1: Coil Objects=Coil_1 Conductor_number=conds Winding=PhaseA PolarityType=Positive
  PhA_2: Coil Objects=Coil_2 Conductor_number=conds Winding=PhaseA PolarityType=Positive
  PhA_3: Coil Objects=Coil_3 Conductor_number=conds Winding=PhaseA PolarityType=Positive
  PhCRe_4: Coil Objects=Coil_4 Conductor_number=conds Winding=PhaseC PolarityType=Negative
  PhCRe_5: Coil Objects=Coil_5 Conductor_number=conds Winding=PhaseC PolarityType=Negative
  PhCRe_6: Coil Objects=Coil_6 Conductor_number=conds Winding=PhaseC PolarityType=Negative
  PhCRe_7: Coil Objects=Coil_7 Conductor_number=conds Winding=PhaseC PolarityType=Negative
  PhB_8: Coil Objects=Coil_8 Conductor_number=conds Winding=PhaseB PolarityType=Positive
  PhB_9: Coil Objects=Coil_9 Conductor_number=conds Winding=PhaseB PolarityType=Positive
  PhB_10: Coil Objects=Coil_10 Conductor_number=conds Winding=PhaseB PolarityType=Positive
  PhB_11: Coil Objects=Coil_11 Conductor_number=conds Winding=PhaseB PolarityType=Positive
  PhA_61: Coil Objects=CoilRe_0 Conductor_number=conds Winding=PhaseA PolarityType=Positive
  PhA_62: Coil Objects=CoilRe_1 Conductor_number=conds Winding=PhaseA PolarityType=Positive
  PhA_63: Coil Objects=CoilRe_2 Conductor_number=conds Winding=PhaseA PolarityType=Positive
  PhCRe_64: Coil Objects=CoilRe_3 Conductor_number=conds Winding=PhaseC PolarityType=Negative
  PhCRe_65: Coil Objects=CoilRe_4 Conductor_number=conds Winding=PhaseC PolarityType=Negative
  PhCRe_66: Coil Objects=CoilRe_5 Conductor_number=conds Winding=PhaseC PolarityType=Negative
  PhCRe_67: Coil Objects=CoilRe_6 Conductor_number=conds Winding=PhaseC PolarityType=Negative
  PhB_68: Coil Objects=CoilRe_7 Conductor_number=conds Winding=PhaseB PolarityType=Positive
  PhB_69: Coil Objects=CoilRe_8 Conductor_number=conds Winding=PhaseB PolarityType=Positive
  PhB_70: Coil Objects=CoilRe_9 Conductor_number=conds Winding=PhaseB PolarityType=Positive
  PhB_71: Coil Objects=CoilRe_10 Conductor_number=conds Winding=PhaseB PolarityType=Positive
  Field_0: Coil Objects=Field_0 Conductor_number=190 Winding=Field PolarityType=Positive
  FieldRe_0: Coil Objects=FieldRe_0 Conductor_number=190 Winding=Field PolarityType=Negative
  PhaseA: Winding Group Type=Current IsSolid=false Current=1500*sin(2*pi*50*time+delta) ParallelBranchesNum=6
  PhaseB: Winding Group Type=Current IsSolid=false Current=1500*sin(2*pi*50*time+delta-2*pi/3) ParallelBranchesNum=6
  PhaseC: Winding Group Type=Current IsSolid=false Current=1500*sin(2*pi*50*time+delta-4*pi/3) ParallelBranchesNum=6
  Field: Winding Group Type=Current IsSolid=false Current=53.2675A ParallelBranchesNum=1
mesh:
  SurfApprox_Main: SurfApproxBased Objects=[Stator, Rotor, Band, OuterRegion, InnerRegion, Shaft] CurvedSurfaceApproxChoice=ManualSettings SurfDev=0.3683mm NormalDev=15deg
  CylindricalGap1: CylindricalGap Objects=Band
  initial mesh: MeshMethod=AnsoftTAU
setups:
  Setup1: Transient NonlinearSolverResidual=0.0001 StopTime=0.2s TimeStep=0.0002s OutputPerObjectCoreLoss InitialTimeStep=0.002s MinTimeStep=0.001s MaxTimeStep=0.003s TimeStepErrTolerance=0.0001
output variables:
  pos = (Moving1.Position -67.5 * PI/180) * 3 + PI
  cos0 = cos(pos)
  cos1 = cos(pos-2*PI/3)
  cos2 = cos(pos-4*PI/3)
  sin0 = sin(pos)
  sin1 = sin(pos-2*PI/3)
  sin2 = sin(pos-4*PI/3)
  Lad = L(PhaseA,PhaseA)*cos0 + L(PhaseA,PhaseB)*cos1 + L(PhaseA,PhaseC)*cos2
  Laq = L(PhaseA,PhaseA)*sin0 + L(PhaseA,PhaseB)*sin1 + L(PhaseA,PhaseC)*sin2
  Lbd = L(PhaseB,PhaseA)*cos0 + L(PhaseB,PhaseB)*cos1 + L(PhaseB,PhaseC)*cos2
  Lbq = L(PhaseB,PhaseA)*sin0 + L(PhaseB,PhaseB)*sin1 + L(PhaseB,PhaseC)*sin2
  Lcd = L(PhaseC,PhaseA)*cos0 + L(PhaseC,PhaseB)*cos1 + L(PhaseC,PhaseC)*cos2
  Lcq = L(PhaseC,PhaseA)*sin0 + L(PhaseC,PhaseB)*sin1 + L(PhaseC,PhaseC)*sin2
  L_d = (Lad*cos0 + Lbd*cos1 + Lcd*cos2) * 2/3
  L_q = (Laq*sin0 + Lbq*sin1 + Lcq*sin2) * 2/3
  Flux_d = (FluxLinkage(PhaseA)*cos0+FluxLinkage(PhaseB)*cos1+FluxLinkage(PhaseC)*cos2)*2/3
  Flux_q = (FluxLinkage(PhaseA)*sin0+FluxLinkage(PhaseB)*sin1+FluxLinkage(PhaseC)*sin2)*2/3
  I_d = (Current(PhaseA)*cos0 + Current(PhaseB)*cos1 + Current(PhaseC)*cos2)*2/3
  I_q = (Current(PhaseA)*sin0 + Current(PhaseB)*sin1 + Current(PhaseC)*sin2)*2/3
  Irms = sqrt(I_d^2+I_q^2)/sqrt(2)
  Pcu = 3*Irms^2*0
reports:
  Torque: Moving1.Torque vs Time on Setup1 : Transient; Moving1.Torque vs Time
  Induced Voltages: InducedVoltage(PhaseA), InducedVoltage(PhaseB), InducedVoltage(PhaseC) vs Time on Setup1 : Transient
  Flux Linkages: FluxLinkage(PhaseA), FluxLinkage(PhaseB), FluxLinkage(PhaseC) vs Time on Setup1 : Transient
  Powers: Moving1.Speed*Moving1.Torque vs Time on Setup1 : Transient
  L_dq: L_d, L_q vs Time on Setup1 : Transient
  Flux_dq: Flux_d, Flux_q vs Time on Setup1 : Transient; Flux_d vs Time
  I_dq: I_d, I_q vs Time on Setup1 : Transient
