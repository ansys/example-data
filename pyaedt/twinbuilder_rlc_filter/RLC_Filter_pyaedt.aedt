# Ansys Electronics Desktop project, version 2026.1
project variables:
  $Vdrive = 5V  # tune 2.5V..7.5V
  $Rseries = 50ohm  # tune 25ohm..75ohm
  $Lseries = 10mH  # tune 5mH..15mH
  $Cshunt = 2.2uF
  $Fsource = 1kHz

design RLC_Filter_Optimetrics (Twin Builder)
components:
  V_IN = E(Type=ESINE EMF=Vin AMPL=$Vdrive FREQ=$Fsource)
  R_SERIES = R(R=$Rseries)
  L_SERIES = L(L=$Lseries)
  C_SHUNT = C(UseInitialConditions=true C=$Cshunt)
nets:
  0: C_SHUNT.1, V_IN.0
  net_12: R_SERIES.1, L_SERIES.0
  net_17: C_SHUNT.0, L_SERIES.1
  net_8: V_IN.1, R_SERIES.0
