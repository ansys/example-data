# Ansys Electronics Desktop project, version 2023.1
project datasets:
  $Ceramic_material_39: (-273.15, 0.067032967) (-196.15, 0.067032967) (99.85, 1) (726.85, 1)
  $Cu_Pure_35: (-273.15, 0.49118388) (-196.15, 0.49118388) (99.85, 1) (726.85, 1)
  $Au_Typical_20: (-273.15, 0.74045802) (-196.15, 0.74045802) (99.85, 1) (726.85, 1)
  $Si_Typical_5: (-273.15, 0.23376623) (-196.15, 0.23376623) (99.85, 1) (726.85, 1)
materials:
  air: permittivity=1.0006 permeability=1.0000004 thermal_conductivity=0.0261 mass_density=1.1614 specific_heat=1006 thermal_expansion_coefficient=0.00333 thermal_material_type=Fluid diffusivity=2.88e-05 molecular_mass=0.028966 viscosity=1.84e-05
  Al-Extruded: thermal_conductivity=205 mass_density=2800 specific_heat=900 thermal_material_type=Solid
  Au-Typical: thermal_modifier{Property=specific_heat free_form_value=pwl($Au_Typical_20,Temp)} thermal_conductivity=313 mass_density=19281 specific_heat=131 thermal_material_type=Solid
  Board_Material: thermal_conductivity{anisotropic component1=35.143 component2=35.143 component3=0.395} mass_density=1250 specific_heat=1300
  Ceramic_material: thermal_modifier{Property=specific_heat free_form_value=pwl($Ceramic_material_39,Temp)} thermal_conductivity=15 mass_density=3970 specific_heat=910 thermal_material_type=Solid
  copper: permeability=0.999991 conductivity=58000000 thermal_conductivity=400 mass_density=8933 specific_heat=385 youngs_modulus=120000000000 poissons_ratio=0.38 thermal_expansion_coefficient=1.77e-05
  Cu-Brass: thermal_modifier{Property=specific_heat free_form_value="if(Temp > 1000cel, 1, if(Temp < -273.15cel, 1, 1))"} thermal_conductivity=130 mass_density=8500 specific_heat=390 thermal_material_type=Solid
  Cu-Pure: thermal_modifier{Property=specific_heat free_form_value=pwl($Cu_Pure_35,Temp)} thermal_conductivity=387.6 mass_density=8933 specific_heat=397 thermal_material_type=Solid
  EDB_AIR: permittivity=1 thermal_conductivity=0.0261 mass_density=1.1614 specific_heat=1005
  EDB_CONFORMAL_COAT: permittivity=3 dielectric_loss_tangent=0.035 thermal_conductivity=0.35 mass_density=1250 specific_heat=1300
  EDB_COPPER: permeability=1 conductivity=59590000 thermal_conductivity=400 mass_density=8933 specific_heat=385
  EDB_FR-4: permittivity=4 dielectric_loss_tangent=0.035 thermal_conductivity=0.35 mass_density=1250 specific_heat=1300
  EDB_PLATED_COPPER_FOIL: permeability=1 conductivity=34300000 thermal_conductivity=387.6 mass_density=8933 specific_heat=397
  Epoxy Resin-Typical: thermal_conductivity=0.2 mass_density=1120 specific_heat=1400 thermal_material_type=Solid
  FR-4: thermal_conductivity=0.35 mass_density=1250 specific_heat=1300 thermal_material_type=Solid
  FR4_epoxy: permittivity=4.4 dielectric_loss_tangent=0.02 thermal_conductivity=0.294 mass_density=1900 specific_heat=1150 youngs_modulus=11000000000 poissons_ratio=0.28 thermal_expansion_coefficient=1.5e-05
  HighConductivityMaterial: thermal_conductivity=5000 mass_density=1 specific_heat=1
  IDF_BoardMaterial: thermal_conductivity{anisotropic component1=21.140086 component2=21.140086 component3=0.42600707} mass_density=1250 specific_heat=1300
  Mold_material: thermal_conductivity=0.8 mass_density=1900 specific_heat=795 thermal_material_type=Solid
  QFP2_foot: thermal_conductivity=((130.0*(2*((0.1mm)*(0.2mm)*(0.5*15.0mm-0.5*8.56mm-1.0mm)*(11))+2*((0.1mm)*(0.2mm)*(0.5*15.0mm-0.5*8.56mm-1.0mm)*(11)))/(2*(0.5*(15.0mm+8.56mm)*(0.5*15.0mm-0.5*8.56mm-1.0mm)*(0.1mm))+2*(0.5*(15.0mm+8.56mm)*(0.5*15.0mm-0.5*8.56mm-1.0mm)*(0.1mm))))+(0.8*(1-(2*((0.1mm)*(0.2mm)*(0.5*15.0mm-0.5*8.56mm-1.0mm)*(11))+2*((0.1mm)*(0.2mm)*(0.5*15.0mm-0.5*8.56mm-1.0mm)*(11)))/(2*(0.5*(15.0mm+8.56mm)*(0.5*15.0mm-0.5*8.56mm-1.0mm)*(0.1mm))+2*(0.5*(15.0mm+8.56mm)*(0.5*15.0mm-0.5*8.56mm-1.0mm)*(0.1mm)))))) mass_density=((8500.0*(2*((0.1mm)*(0.2mm)*(0.5*15.0mm-0.5*8.56mm-1.0mm)*(11))+2*((0.1mm)*(0.2mm)*(0.5*15.0mm-0.5*8.56mm-1.0mm)*(11)))/(2*(0.5*(15.0mm+8.56mm)*(0.5*15.0mm-0.5*8.56mm-1.0mm)*(0.1mm))+2*(0.5*(15.0mm+8.56mm)*(0.5*15.0mm-0.5*8.56mm-1.0mm)*(0.1mm))))+(1900.0*(1-(2*((0.1mm)*(0.2mm)*(0.5*15.0mm-0.5*8.56mm-1.0mm)*(11))+2*((0.1mm)*(0.2mm)*(0.5*15.0mm-0.5*8.56mm-1.0mm)*(11)))/(2*(0.5*(15.0mm+8.56mm)*(0.5*15.0mm-0.5*8.56mm-1.0mm)*(0.1mm))+2*(0.5*(15.0mm+8.56mm)*(0.5*15.0mm-0.5*8.56mm-1.0mm)*(0.1mm)))))) specific_heat=((390.0*(2*((0.1mm)*(0.2mm)*(0.5*15.0mm-0.5*8.56mm-1.0mm)*(11))+2*((0.1mm)*(0.2mm)*(0.5*15.0mm-0.5*8.56mm-1.0mm)*(11)))/(2*(0.5*(15.0mm+8.56mm)*(0.5*15.0mm-0.5*8.56mm-1.0mm)*(0.1mm))+2*(0.5*(15.0mm+8.56mm)*(0.5*15.0mm-0.5*8.56mm-1.0mm)*(0.1mm))))+(795.0*(1-(2*((0.1mm)*(0.2mm)*(0.5*15.0mm-0.5*8.56mm-1.0mm)*(11))+2*((0.1mm)*(0.2mm)*(0.5*15.0mm-0.5*8.56mm-1.0mm)*(11)))/(2*(0.5*(15.0mm+8.56mm)*(0.5*15.0mm-0.5*8.56mm-1.0mm)*(0.1mm))+2*(0.5*(15.0mm+8.56mm)*(0.5*15.0mm-0.5*8.56mm-1.0mm)*(0.1mm))))))
  QFP2_lead: thermal_conductivity=((130.0*(2*((0.1mm)*(0.2mm)*(0.5*15.0mm-0.5*8.56mm-1.0mm)*(11))+2*((0.1mm)*(0.2mm)*(0.5*15.0mm-0.5*8.56mm-1.0mm)*(11)))/(2*(0.5*(15.0mm+8.56mm)*(0.5*15.0mm-0.5*8.56mm-1.0mm)*(0.1mm))+2*(0.5*(15.0mm+8.56mm)*(0.5*15.0mm-0.5*8.56mm-1.0mm)*(0.1mm))))+(0.8*(1-(2*((0.1mm)*(0.2mm)*(0.5*15.0mm-0.5*8.56mm-1.0mm)*(11))+2*((0.1mm)*(0.2mm)*(0.5*15.0mm-0.5*8.56mm-1.0mm)*(11)))/(2*(0.5*(15.0mm+8.56mm)*(0.5*15.0mm-0.5*8.56mm-1.0mm)*(0.1mm))+2*(0.5*(15.0mm+8.56mm)*(0.5*15.0mm-0.5*8.56mm-1.0mm)*(0.1mm)))))) mass_density=((8500.0*(2*((0.1mm)*(0.2mm)*(0.5*15.0mm-0.5*8.56mm-1.0mm)*(11))+2*((0.1mm)*(0.2mm)*(0.5*15.0mm-0.5*8.56mm-1.0mm)*(11)))/(2*(0.5*(15.0mm+8.56mm)*(0.5*15.0mm-0.5*8.56mm-1.0mm)*(0.1mm))+2*(0.5*(15.0mm+8.56mm)*(0.5*15.0mm-0.5*8.56mm-1.0mm)*(0.1mm))))+(1900.0*(1-(2*((0.1mm)*(0.2mm)*(0.5*15.0mm-0.5*8.56mm-1.0mm)*(11))+2*((0.1mm)*(0.2mm)*(0.5*15.0mm-0.5*8.56mm-1.0mm)*(11)))/(2*(0.5*(15.0mm+8.56mm)*(0.5*15.0mm-0.5*8.56mm-1.0mm)*(0.1mm))+2*(0.5*(15.0mm+8.56mm)*(0.5*15.0mm-0.5*8.56mm-1.0mm)*(0.1mm)))))) specific_heat=((390.0*(2*((0.1mm)*(0.2mm)*(0.5*15.0mm-0.5*8.56mm-1.0mm)*(11))+2*((0.1mm)*(0.2mm)*(0.5*15.0mm-0.5*8.56mm-1.0mm)*(11)))/(2*(0.5*(15.0mm+8.56mm)*(0.5*15.0mm-0.5*8.56mm-1.0mm)*(0.1mm))+2*(0.5*(15.0mm+8.56mm)*(0.5*15.0mm-0.5*8.56mm-1.0mm)*(0.1mm))))+(795.0*(1-(2*((0.1mm)*(0.2mm)*(0.5*15.0mm-0.5*8.56mm-1.0mm)*(11))+2*((0.1mm)*(0.2mm)*(0.5*15.0mm-0.5*8.56mm-1.0mm)*(11)))/(2*(0.5*(15.0mm+8.56mm)*(0.5*15.0mm-0.5*8.56mm-1.0mm)*(0.1mm))+2*(0.5*(15.0mm+8.56mm)*(0.5*15.0mm-0.5*8.56mm-1.0mm)*(0.1mm))))))
  QFP2_wire: thermal_conductivity=(313.0*(44*0.25*3.14159265359*0.025mm*0.025mm)/(2*(8.56mm+8.56mm)*0.025mm))+(0.8*(1-(44*0.25*3.14159265359*0.025mm*0.025mm)/(2*(8.56mm+8.56mm)*0.025mm))) mass_density=(19281.0*(44*0.25*3.14159265359*0.025mm*0.025mm)/(2*(8.56mm+8.56mm)*0.025mm))+(1900.0*(1-(44*0.25*3.14159265359*0.025mm*0.025mm)/(2*(8.56mm+8.56mm)*0.025mm))) specific_heat=(131.0*(44*0.25*3.14159265359*0.025mm*0.025mm)/(2*(8.56mm+8.56mm)*0.025mm))+(795.0*(1-(44*0.25*3.14159265359*0.025mm*0.025mm)/(2*(8.56mm+8.56mm)*0.025mm)))
  Si-Typical: thermal_modifier{Property=specific_heat free_form_value=pwl($Si_Typical_5,Temp)} thermal_conductivity=180 mass_density=2330 specific_heat=770 thermal_material_type=Solid
surface materials:
  Steel-oxidised-surface: surface_emissivity=0.8

design Model (Icepak, SteadyState TemperatureAndFlow, model units mm)
options: Default_Fluid_Material=air Default_Solid_Material=Al-Extruded Default_Surface_Material=Steel-oxidised-surface AmbientTemperature=20cel AmbientPressure=0n_per_meter_sq AmbientRadiationTemperature=20cel Gravity_Vector_CS_ID=Global Gravity_Vector_Axis=Z Positive=false Altitude=0meter
datasets:
  AGP: (-273, 1) (0, 1) (50, 2) (100, 2) (150, 2.5)
  PowerDissipationDataset: units cel, W: (45, 0.5) (53, 3) (60, 6) (70, 9)
geometry:
  coordinate_system Fan_Coord = origin=(-25mm, -20mm, 10mm) Euler Angle ZYZ phi=0deg theta=0deg psi=0deg
  Fans1 = component(Fans, Type=Fan Unit=mm ModelAs=3D Shape=Circular MovePlane=YZ Radius=9.293mm HubRadius=3.293mm CaseSize=26mm CaseHeight=6mm CaseSide SheetID=43 BodyID=34 HubID=49 CaseID=6 FlowDirChoice=NormalPositive FlowType=Curve SwirlType=Magnitude SolidCaseMaterial=Al-Extruded SolidHubMaterial=Al-Extruded PassageMaterial=Air DimUnits("", "") X(0, 0.000141, 0.000376, 0.0005875, 0.0006815, 0.0008225) Y(74.725, 64.671, 44.835, 24.908, 12.454, 0) Pressure_Loss_Curve{DimUnits("", "")} IntakeTemp=AmbientTemp Swirl=0 OperatingRPM=0 HubPower=0W Magnitude=1)
  Fans_Passage [Al-Extruded] = part_of(Fans1) in Fan_Coord
  Large_Flash [Ceramic_material] = box(corner=(37mm, -53mm, 1.53mm), size=(16mm, 14mm, 3.5mm))
  Small_Flash [Ceramic_material] = box(corner=(22.7mm, -24.7mm, 1.53mm), size=(7.5mm, 9mm, 1.8mm))
  DDR [Ceramic_material] = box(corner=(130mm, -15mm, 1.53mm), size=(23mm, 13mm, 1.2mm))
  DDR_1 [Ceramic_material] = DDR.duplicate_along_line(step=(0mm, -18mm, 0mm), total=2)
  DDR_3 [Ceramic_material] = DDR_1.duplicate_along_line(step=(0mm, -43mm, 0mm), total=2)
  DDR_2 [Ceramic_material] = DDR.duplicate_along_line(step=(0mm, -43mm, 0mm), total=2)
  Bridge [Ceramic_material] = box(corner=(74mm, -96.5mm, 1.53mm), size=(35.5mm, 28.8mm, 2.5mm))
  Fans_Passage_1 [Air] = part_of(Fans1) in Fan_Coord
  Fans_Surface = part_of(Fans1) in Fan_Coord
  Fans_Hub [Al-Extruded] = part_of(Fans1) in Fan_Coord
  AGP_IDF [HighConductivityMaterial] = box(corner=(73.8896mm, -57.0304mm, 1.56464mm), size=(37.5mm, 37.5mm, 96mil))
  PCB1_1 = component(PCB1, Type=PCB Unit=mm MovePlane=XY ExtentsType="Bounding Box" OutlinePolygon=poly_0 BoardCutoutMaterial=Air PartsChoice=0 BBoxPolygon("cw=false", "cl=true", "pt(U='mm', x=-4.953, y=-106.146, x=162.686, y=-106.146, x=162.686, y=5.0038, x=-4.953, y=5.0038, x=-4.953, y=-106.146)") EdbLayerInfoMap{oneLayerInfo{LayerIndex=1 LayerName=UNNAMED_001 LayerMaterial=FR4_epoxy Thickness=0.01778mm LayerLowerElevation=1.54686mm LayerType=1 3D_Layout_Model_Unit=36} oneLayerInfo{LayerIndex=2 LayerName=TOP LayerMaterial=copper Thickness=0.05588mm LayerLowerElevation=1.49098mm LayerType=0 3D_Layout_Model_Unit=36} oneLayerInfo{LayerIndex=3 LayerName=UNNAMED_003 LayerMaterial=FR4_epoxy Thickness=0.11938mm LayerLowerElevation=1.3716mm LayerType=1 3D_Layout_Model_Unit=36} oneLayerInfo{LayerIndex=4 LayerName=INT1 LayerMaterial=copper Thickness=0.03048mm LayerLowerElevation=1.34112mm LayerType=0 3D_Layout_Model_Unit=36} oneLayerInfo{LayerIndex=5 LayerName=UNNAMED_005 LayerMaterial=FR4_epoxy Thickness=1.1176mm LayerLowerElevation=0.22352mm LayerType=1 3D_Layout_Model_Unit=36} oneLayerInfo{LayerIndex=6 LayerName=INT2 LayerMaterial=copper Thickness=0.03048mm LayerLowerElevation=0.19304mm LayerType=0 3D_Layout_Model_Unit=36} oneLayerInfo{LayerIndex=7 LayerName=UNNAMED_007 LayerMaterial=FR4_epoxy Thickness=0.11938mm LayerLowerElevation=0.07366mm LayerType=1 3D_Layout_Model_Unit=36} oneLayerInfo{LayerIndex=8 LayerName=BOTTOM LayerMaterial=copper Thickness=0.05588mm LayerLowerElevation=0.01778mm LayerType=0 3D_L)
  PCB1_009_UNNAMED_009_BBox, PCB1_001_UNNAMED_001_BBox [FR4_epoxy, surface Steel-Oxidised-surface] = part_of(PCB1_1)
  PCB1_002_TOP_BBox [copper, surface Steel-Oxidised-surface] = part_of(PCB1_1)
  PCB1_003_UNNAMED_003_BBox [FR4_epoxy, surface Steel-Oxidised-surface] = part_of(PCB1_1)
  PCB1_004_INT1_BBox [copper, surface Steel-Oxidised-surface] = part_of(PCB1_1)
  PCB1_005_UNNAMED_005_BBox [FR4_epoxy, surface Steel-Oxidised-surface] = part_of(PCB1_1)
  PCB1_006_INT2_BBox [copper, surface Steel-Oxidised-surface] = part_of(PCB1_1)
  PCB1_007_UNNAMED_007_BBox [FR4_epoxy, surface Steel-Oxidised-surface] = part_of(PCB1_1)
  PCB1_008_BOTTOM_BBox [copper, surface Steel-Oxidised-surface] = part_of(PCB1_1)
  [Large_Flash, Small_Flash, DDR, DDR_1, DDR_3, DDR_2, Bridge].move(0mm, 0mm, 0.01686mm)
  plane Plane1 = base (162.686mm, 5.0038mm, 1.35636mm) normal (0mm, 0mm, 0.01524mm)
  DomainBox_ObjectFromFace1..DomainBox_ObjectFromFace6 [Al-Extruded] = imported_body()
  Region [air, oriented by Fan_Coord] = region(percentage_offset=0 on all sides) in Fan_Coord
  coordinate_system RelativeCS1 = origin=(0mm, -60mm, 0mm) x=(1mm, 0mm, 0mm) y=(0mm, 1mm, 0mm) in Fan_Coord
  Fans2 = component(Fans, Type=Fan Unit=mm ModelAs=3D Shape=Circular MovePlane=YZ Radius=9.293mm HubRadius=3.293mm CaseSize=26mm CaseHeight=6mm CaseSide SheetID=43 BodyID=34 HubID=49 CaseID=6 FlowDirChoice=NormalPositive FlowType=Curve SwirlType=Magnitude SolidCaseMaterial=Al-Extruded SolidHubMaterial=Al-Extruded PassageMaterial=Air DimUnits("", "") X(0, 0.000141, 0.000376, 0.0005875, 0.0006815, 0.0008225) Y(74.725, 64.671, 44.835, 24.908, 12.454, 0) Pressure_Loss_Curve{DimUnits("", "")} IntakeTemp=AmbientTemp Swirl=0 OperatingRPM=0 HubPower=0W Magnitude=1)
  Fans_Case2 [Al-Extruded] = part_of(Fans2) in RelativeCS1
  Fans_Passage2 [Air] = part_of(Fans2) in RelativeCS1
  Fans_Surface2 = part_of(Fans2) in RelativeCS1
  Fans_Hub2 [Al-Extruded] = part_of(Fans2) in RelativeCS1
  point Point_6XWI34 = (92.6396mm, -38.2804mm, 24.00304mm)
  QFP_Mesh [non-model] = imported_body()
  priority 3: Bridge, DDR, DDR_1, DDR_2, DDR_3, Large_Flash, Small_Flash, AGP_IDF
  group Case = DomainBox_ObjectFromFace1..DomainBox_ObjectFromFace6
boundaries and excitations:
  maxX_Grille: Grille Objects=DomainBox_ObjectFromFace5 Pressure_Loss_Type=Coeff Free_Area_Ratio=1 Resistance_Type="Perforated Thin Vent" External_Rad._Temperature=AmbientTemp External_Total_Pressure=AmbientPressure DimUnits("", "") X(0, 1, 2) Y(0, 1, 2)
  sidewalls: Stationary Wall Faces=DomainBox_ObjectFromFace4.face(at (75, -50.5711, -10)) DomainBox_ObjectFromFace6.face(at (-25, -50.5711, 12.5)) DomainBox_ObjectFromFace3.face(at (75, 15.0038, 12.5)) DomainBox_ObjectFromFace2.face(at (75, -50.5711, 35)) DomainBox_ObjectFromFace1.face(at (75, -116.146, 12.5)) Thickness=0mm Solid_Material=Al-Extruded External_Condition="Heat Transfer Coefficient" Heat_Flux=0uW_per_m2 Temperature=AmbientTemp Heat_Transfer_Coefficient=10w_per_m2kel Reference_Temperature=AmbientTemp Heat_Transfer_Data{Heat_Transfer_Convection_Type="Forced Convection"} External_Material=Steel-oxidised-surface External_Radiation_Reference_Temperature=AmbientTemp External_Radiation_View_Factor=1
  Large_Flash: Block Objects=Large_Flash Block_Type=Solid Total_Power=0.5W
  Small_Flash: Block Objects=Small_Flash Block_Type=Solid Total_Power=0.25W
  Bridge: Block Objects=Bridge Block_Type=Solid Total_Power=2.5W
  AGP_IDF: Block Objects=AGP_IDF Block_Type=Solid Total_Power_Variation_Data{Variation_Type="Temp Dep" Variation_Function="Piecewise Linear" Variation_Value='["1W", "pwl(AGP,Temp)"]'}
  DDR: Network Faces=DDR.face(-z, +z) Nodes{Case{FaceID=DDR.face(+z) ThermalResistance=NoResistance Thickness=1mm Material=Al-Extruded Resistance=0cel_per_w} Board{FaceID=DDR.face(-z) ThermalResistance=NoResistance Thickness=1mm Material=Al-Extruded Resistance=0cel_per_w} Junction{NodeType=InternalNode Power=1.25W Mass=0.001kg SpecificHeat=1000J_per_Kelkg}} Links{Rthjc(Case, Junction, R-Link, R, 10cel_per_w) Rthjb(Junction, Board, R-Link, R, 4cel_per_w)} SchematicData{Junction{SchCompInst(0.0254, -0.00254, 0) PropDisplayMap{Name(4, 5, 0, "Text(0.02273965, -0.00684881, 0, 1, 5, false, 'Arial', 0, 'Junction', false, false, ExtentRect(0, 0, 0, 0, 0.0256576782601491, -0.00630556005795097, 0.00583605652029818, 0.00176944266838828, 0, 0, 0))")}} Board{SchCompInst(0.0508, -0.00254, 0) PropDisplayMap{Name(4, 5, 0, "Text(0.04813965, -0.00510281, 0, 1, 5, false, 'Arial', 0, 'Board', false, false, ExtentRect(0, 0, 0, 0, 0.050219521206702, -0.00455956005795097, 0.00415974241340402, 0.00176944266838828, 0, 0, 0))")}} Case{SchCompInst(0.01016, -0.00254, 0) PropDisplayMap{Name(4, 5, 0, "Text(0.00749965, -0.00510281, 0, 1, 5, false, 'Arial', 0, 'Case', false, false, ExtentRect(0, 0, 0, 0, 0.00931565694913534, -0.00455956005795097, 0.00363201389827068, 0.00176944266838828, 0, 0, 0))")}} Rthjb{SchCompInst(0.04064, -0.00254, 0) PropDisplayMap{Name(4, 5, 0, "Text(0.03924965, -0.00511881, 0, 1, 5, false, 'Arial', 0, 'Rthjb', false, false, ExtentRect(0, 0, 0, 0, 0.0410501355222197, -0.00457556005795097, 0.0036009710444393, 0.00176944266838828, 0, 0, 0))")}} Rthjc{SchCompInst(0.02032, -0.00254, 0) PropDisplayMap{Name(4, 5, 0, "Text(0.01892965, -0.00511881, 0, 1, 5, false, 'Arial', 0, 'Rthjc', false, false, ExtentRect(0, 0, 0, 0, 0.0206835712414726, -0.00457556005795097, 0.00350784248294518, 0.00176944266838828, 0, 0, 0))")}} WireData{Page{PageNet{NetName=Case WireSeg(0.01016, -0.00254, 0.01524, -0.00254, 0) PC(15, n1) PC(16, n1)} PageNet{NetName=Junction WireSeg(0.0254, -0.00254, 0.03556, -0.00254, 2) PC(16, n2) PC(17, n1) PC(18, n1)} PageNet{NetName=Board WireSeg(0.0508, -0.00254, 0.04572, -0.00254, 3) PC(18, n2) PC(19, n1)}}} NodeTailsHidden}
  DDR1: Network Faces=DDR_1.face(at (141.5, -26.5, 1.54686), at (141.5, -26.5, 2.74686)) Nodes{Case{FaceID=DDR_1.face(at (141.5, -26.5, 2.74686)) ThermalResistance=NoResistance Thickness=1mm Material=Al-Extruded Resistance=0cel_per_w} Base{FaceID=DDR_1.face(at (141.5, -26.5, 1.54686)) ThermalResistance=NoResistance Thickness=1mm Material=Al-Extruded Resistance=0cel_per_w} Junction{NodeType=InternalNode Power=1.25W Mass=0.001kg SpecificHeat=1000J_per_Kelkg}} Links{Rthjc(Case, Junction, R-Link, R, 10cel_per_w) Rthjb(Junction, Base, R-Link, R, 4cel_per_w)} SchematicData{Junction{SchCompInst(0.0254, -0.00254, 0) PropDisplayMap{Name(4, 5, 0, "Text(0.02273965, -0.00684881, 0, 1, 5, false, 'Arial', 0, 'Junction', false, false, ExtentRect(0, 0, 0, 0, 0.0256332070602524, -0.00631011586644237, 0.0057871141205048, 0.00175460374930199, 0, 0, 0))")}} Case{SchCompInst(0.01016, -0.00254, 0) PropDisplayMap{Name(4, 5, 0, "Text(0.00749965, -0.00510281, 0, 1, 5, false, 'Arial', 0, 'Case', false, false, ExtentRect(0, 0, 0, 0, 0.00930042753217836, -0.00456411586644237, 0.00360155506435671, 0.00175460374930199, 0, 0, 0))")}} Base{SchCompInst(0.0508, -0.00254, 0) PropDisplayMap{Name(4, 5, 0, "Text(0.04813965, -0.00510281, 0, 1, 5, false, 'Arial', 0, 'Base', false, false, ExtentRect(0, 0, 0, 0, 0.049894253749302, -0.00456411586644237, 0.00350920749860397, 0.00175460374930199, 0, 0, 0))")}} Rthjc{SchCompInst(0.02032, -0.00254, 0) PropDisplayMap{Name(4, 5, 0, "Text(0.01892965, -0.00511881, 0, 1, 5, false, 'Arial', 0, 'Rthjc', false, false, ExtentRect(0, 0, 0, 0, 0.0206688624883432, -0.00458011586644237, 0.00347842497668639, 0.00175460374930199, 0, 0, 0))")}} Rthjb{SchCompInst(0.04064, -0.00254, 0) PropDisplayMap{Name(4, 5, 0, "Text(0.03924965, -0.00511881, 0, 1, 5, false, 'Arial', 0, 'Rthjb', false, false, ExtentRect(0, 0, 0, 0, 0.0410350362712196, -0.00458011586644237, 0.00357077254243913, 0.00175460374930199, 0, 0, 0))")}} WireData{Page{PageNet{NetName=Case WireSeg(0.01016, -0.00254, 0.01524, -0.00254, 7) PC(20, n1) PC(21, n1)} PageNet{NetName=Junction WireSeg(0.0254, -0.00254, 0.03556, -0.00254, 9) PC(21, n2) PC(22, n1) PC(23, n1)} PageNet{NetName=Base WireSeg(0.0508, -0.00254, 0.04572, -0.00254, 10) PC(23, n2) PC(24, n1)}}} NodeTailsHidden}
  DDR2: Network Faces=DDR_2.face(at (141.5, -51.5, 1.54686), at (141.5, -51.5, 2.74686)) Nodes{Case{FaceID=DDR_2.face(at (141.5, -51.5, 2.74686)) ThermalResistance=NoResistance Thickness=1mm Material=Al-Extruded Resistance=0cel_per_w} Board{FaceID=DDR_2.face(at (141.5, -51.5, 1.54686)) ThermalResistance=NoResistance Thickness=1mm Material=Al-Extruded Resistance=0cel_per_w} Junction{NodeType=InternalNode Power=2W Mass=0.001kg SpecificHeat=1000J_per_Kelkg}} Links{Rthjc(Case, Junction, R-Link, R, 10cel_per_w) Rthjb(Junction, Board, R-Link, R, 4cel_per_w)} SchematicData{Case{SchCompInst(0.01016, -0.00254, 0) PropDisplayMap{Name(4, 5, 0, "Text(0.00749965, -0.00510281, 0, 1, 5, false, 'Arial', 0, 'Case', false, false, ExtentRect(0, 0, 0, 0, 0.00932070555940018, -0.00453876624266366, 0.00364211111880036, 0.00177270895162849, 0, 0, 0))")}} Board{SchCompInst(0.0508, -0.00254, 0) PropDisplayMap{Name(4, 5, 0, "Text(0.04813965, -0.00510281, 0, 1, 5, false, 'Arial', 0, 'Board', false, false, ExtentRect(0, 0, 0, 0, 0.0502185541341825, -0.00453876624266366, 0.00415780826836501, 0.00177270895162849, 0, 0, 0))")}} Junction{SchCompInst(0.0254, -0.00254, 0) PropDisplayMap{Name(4, 5, 0, "Text(0.02273965, -0.00684881, 0, 1, 5, false, 'Arial', 0, 'Junction', false, false, ExtentRect(0, 0, 0, 0, 0.0256243309303773, -0.00628476624266366, 0.00576936186075455, 0.00177270895162849, 0, 0, 0))")}} Rthjb{SchCompInst(0.04064, -0.00254, 0) PropDisplayMap{Name(4, 5, 0, "Text(0.03924965, -0.00511881, 0, 1, 5, false, 'Arial', 0, 'Rthjb', false, false, ExtentRect(0, 0, 0, 0, 0.0410545900234763, -0.00455476624266366, 0.00360988004695256, 0.00177270895162849, 0, 0, 0))")}} Rthjc{SchCompInst(0.02032, -0.00254, 0) PropDisplayMap{Name(4, 5, 0, "Text(0.01892965, -0.00511881, 0, 1, 5, false, 'Arial', 0, 'Rthjc', false, false, ExtentRect(0, 0, 0, 0, 0.0206862434157046, -0.00455476624266366, 0.00351318683140919, 0.00177270895162849, 0, 0, 0))")}} WireData{Page{PageNet{NetName=Face304 WireSeg(0.01016, -0.00254, 0.01524, -0.00254, 17) PC(25, n1) PC(26, n1)} PageNet{NetName=Internal WireSeg(0.0254, -0.00254, 0.03556, -0.00254, 19) PC(26, n2) PC(28, n1) PC(27, n1)} PageNet{NetName=Face305 WireSeg(0.0508, -0.00254, 0.04572, -0.00254, 20) PC(29, n1) PC(28, n2)}}} NodeTailsHidden}
  DDR3: Network Faces=DDR_3.face(at (141.5, -69.5, 1.54686), at (141.5, -69.5, 2.74686)) Nodes{Case{FaceID=DDR_3.face(at (141.5, -69.5, 2.74686)) ThermalResistance=NoResistance Thickness=1mm Material=Al-Extruded Resistance=0cel_per_w} Board{FaceID=DDR_3.face(at (141.5, -69.5, 1.54686)) ThermalResistance=NoResistance Thickness=1mm Material=Al-Extruded Resistance=0cel_per_w} Junction{NodeType=InternalNode Power=2W Mass=0.001kg SpecificHeat=1000J_per_Kelkg}} Links{Rthjc(Case, Junction, R-Link, R, 10cel_per_w) Rthjb(Junction, Board, R-Link, R, 4cel_per_w)} SchematicData{Junction{SchCompInst(0.0254, -0.00254, 0) PropDisplayMap{Name(4, 5, 0, "Text(0.02273965, -0.00684881, 0, 1, 5, false, 'Arial', 0, 'Junction', false, false, ExtentRect(0, 0, 0, 0, 0.0256243309303773, -0.00628476624266366, 0.00576936186075455, 0.00177270895162849, 0, 0, 0))")}} Board{SchCompInst(0.0508, -0.00254, 0) PropDisplayMap{Name(4, 5, 0, "Text(0.04813965, -0.00510281, 0, 1, 5, false, 'Arial', 0, 'Board', false, false, ExtentRect(0, 0, 0, 0, 0.0502185541341825, -0.00453876624266366, 0.00415780826836501, 0.00177270895162849, 0, 0, 0))")}} Case{SchCompInst(0.01016, -0.00254, 0) PropDisplayMap{Name(4, 5, 0, "Text(0.00749965, -0.00510281, 0, 1, 5, false, 'Arial', 0, 'Case', false, false, ExtentRect(0, 0, 0, 0, 0.00932070555940018, -0.00453876624266366, 0.00364211111880036, 0.00177270895162849, 0, 0, 0))")}} Rthjc{SchCompInst(0.02032, -0.00254, 0) PropDisplayMap{Name(4, 5, 0, "Text(0.01892965, -0.00511881, 0, 1, 5, false, 'Arial', 0, 'Rthjc', false, false, ExtentRect(0, 0, 0, 0, 0.0206862434157046, -0.00455476624266366, 0.00351318683140919, 0.00177270895162849, 0, 0, 0))")}} Rthjb{SchCompInst(0.04064, -0.00254, 0) PropDisplayMap{Name(4, 5, 0, "Text(0.03924965, -0.00511881, 0, 1, 5, false, 'Arial', 0, 'Rthjb', false, false, ExtentRect(0, 0, 0, 0, 0.0410545900234763, -0.00455476624266366, 0.00360988004695256, 0.00177270895162849, 0, 0, 0))")}} WireData{Page{PageNet{NetName=Face275 WireSeg(0.01016, -0.00254, 0.01524, -0.00254, 21) PC(30, n1) PC(31, n1)} PageNet{NetName=Internal WireSeg(0.0254, -0.00254, 0.03556, -0.00254, 23) PC(31, n2) PC(33, n1) PC(32, n1)} PageNet{NetName=Face276 WireSeg(0.0508, -0.00254, 0.04572, -0.00254, 24) PC(34, n1) PC(33, n2)}}} NodeTailsHidden}
mesh:
  MeshRegions:  Global{MeshMethod=MesherHD UserSpecifiedSettings ComputeGap MaxElementSizeX=5mm MaxElementSizeY=2mm MaxElementSizeZ=1mm MinElementsInGap=3 MinElementsOnEdge=1 MaxSizeRatio=2 NoOGrids EnableMLM EnforeMLMType=2D MaxLevels=2 BufferLayers=1 UniformMeshParametersType="XYZ Max Sizes" MinGapX=1um MinGapY=1um MinGapZ=1um Objects=Region FacetLevel=3 ProximitySizeFunction CurvatureSizeFunction OptimizePCBMesh} QFP_MeshRegion{MeshMethod=MesherHD UserSpecifiedSettings MaxElementSizeX=2mm MaxElementSizeY=2mm MaxElementSizeZ=0.7mm MinElementsInGap=3 MinElementsOnEdge=2 MaxSizeRatio=2 EnableMLM EnforeMLMType=2D MaxLevels=2 BufferLayers=1 UniformMeshParametersType="XYZ Max Sizes" 2DMLMType=2DMLM_XY MinGapX=1um MinGapY=1um MinGapZ=1um Objects=QFP_Mesh ProximitySizeFunction CurvatureSizeFunction OptimizePCBMesh}
  MeshOperations:
monitors:
  Bridge_Monitor: Quantities(19) Objects=Bridge
  LargeFlash_Monitor: Quantities(19) Objects=Large_Flash
  Fan_Monitor: Quantities(16) Faces=Fans_Passage2.face(at (-19, -80, 10))
  Board_Monitor: Quantities(19) Faces=PCB1_001_UNNAMED_001_BBox.face(at (78.8665, -50.5711, 1.56464))
setups:
  ECAD_Model: IcepakSteadyState Flow_Regime=Turbulent Turbulent_Model_Eqn=ZeroEquation Include_Temperature=true Include_Flow=true Solution_Initialization_-_Turbulent_Kinetic_Energy=1m2_per_s2 Solution_Initialization_-_Turbulent_Dissipation_Rate=1m2_per_s3 Solution_Initialization_-_Specific_Dissipation_Rate=1diss_per_s Convergence_Criteria_-_Flow=0.001 Convergence_Criteria_-_Energy=1e-14 Convergence_Criteria_-_Turbulent_Kinetic_Energy=0.001 Convergence_Criteria_-_Turbulent_Dissipation_Rate=0.001 Convergence_Criteria_-_Specific_Dissipation_Rate=0.001 disabled Radiation_Model=Off Under-relaxation_-_Pressure=0.3 Under-relaxation_-_Momentum=0.7 Under-relaxation_-_Temperature=1 Under-relaxation_-_Turbulent_Kinetic_Energy=0.8 Under-relaxation_-_Turbulent_Dissipation_Rate=0.8 Under-relaxation_-_Specific_Dissipation_Rate=0.8 Discretization_Scheme_-_Pressure=Standard Discretization_Scheme_-_Momentum=First Discretization_Scheme_-_Temperature=First Discretization_Scheme_-_Turbulent_Kinetic_Energy=First Discretization_Scheme_-_Turbulent_Dissipation_Rate=First Discretization_Scheme_-_Specific_Dissipation_Rate=First Convergence_Criteria_-_Max_Iterations=500
field plots:
  Velocity_Plane, ECAD_velocity: Velocity over a plane on ECAD_Model : SteadyState
  Temperature1: Temperature over Large_Flash, Small_Flash, DDR, DDR_1, DDR_3, DDR_2, Bridge, AGP_IDF, PCB1_009_UNNAMED_009_BBox, PCB1_001_UNNAMED_001_BBox, PCB1_002_TOP_BBox, PCB1_003_UNNAMED_003_BBox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 on ECAD_Model : SteadyState
