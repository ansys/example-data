# Ansys Electronics Desktop project, version 2026.1
materials:
  vacuum: permittivity=1
  NO18-1160_180C_SF0.97: permeability{HUnit=A_per_meter BUnit=tesla curve (0, 0) (20, 0.065) (30, 0.18) (50, 0.58) (70, 0.83) (100, 1.03) (150, 1.18) (200, 1.24) (400, 1.36) (800, 1.43) (1500, 1.49) (2500, 1.54) (5000, 1.64) (7500, 1.71) (10000, 1.76) (20000, 1.88) (24912.312, 1.924364213) (39800.021, 1.985186079) (65139.583, 2.034030015) (101815.16, 2.086100107) (151295.1, 2.150546545) (216000, 2.232813423) (300140.01, 2.338990911) (412000, 2.479782191) (572827.9, 2.682006693) (1000000, 3.218894976)} conductivity=1612903.2 core_loss_type="Electrical Steel" core_loss_kh=120.96408 core_loss_kc=0.19939424 mass_density=7650 stacking_type=Lamination stacking_factor=0.97 stacking_direction=V(3) core_loss_es_y=2
  Copper (Pure)_20C [ref. Temp]: thermal_modifier{Property=conductivity free_form_value=1/(1+0.003862*(Temp-20))} conductivity=58004640
  NO18-1160_140C_SF0.97: permeability{HUnit=A_per_meter BUnit=tesla curve (0, 0) (20, 0.065) (30, 0.18) (50, 0.58) (70, 0.83) (100, 1.03) (150, 1.18) (200, 1.24) (400, 1.36) (800, 1.43) (1500, 1.49) (2500, 1.54) (5000, 1.64) (7500, 1.71) (10000, 1.76) (20000, 1.88) (24912.312, 1.924364213) (39800.021, 1.985186079) (65139.583, 2.034030015) (101815.16, 2.086100107) (151295.1, 2.150546545) (216000, 2.232813423) (300140.01, 2.338990911) (412000, 2.479782191) (572827.9, 2.682006693) (1000000, 3.218894976)} conductivity=1612903.2 core_loss_type="Electrical Steel" core_loss_kh=120.96408 core_loss_kc=0.19939424 mass_density=7650 stacking_type=Lamination stacking_factor=0.97 stacking_direction=V(3) core_loss_es_y=2
  Stahl 37_80C_2D3DFactShaft: permeability{HUnit=A_per_meter BUnit=tesla curve (0, 0) (10, 0.1) (25, 0.2) (50.5, 0.3) (100, 0.4) (150, 0.5) (210, 0.6) (330, 0.7) (480, 0.8) (620, 0.9) (750, 1) (870, 1.1) (1080, 1.2) (1340, 1.3) (1850, 1.4) (2800, 1.5) (4350, 1.6) (6800, 1.7) (10800, 1.8) (18200.1514, 1.9) (29000, 2) (45000, 2.1) (49786.998, 2.126581801) (64294.918, 2.181561309) (88988.063, 2.238897594) (124728.04, 2.297915664) (172945.74, 2.365525594) (236000, 2.44828349) (317993.59, 2.553154625) (427000, 2.691138224) (583725.15, 2.888664952) (1000000, 3.41221155)} conductivity=6993007 core_loss_type="Electrical Steel" mass_density=7800 core_loss_es_y=2
  N42EH_20C [ref. Temp]_2D3DFactMagnet: thermal_modifier{Property=permeability free_form_value="1 - 0.0012*(Temp - 20)"} thermal_modifier{Property=conductivity free_form_value=1} thermal_modifier{Property=magnetic_coercivity free_form_value="1 - 0.0042*(Temp - 20)"} permeability{BTypeForSingleCurve=intrinsic HUnit=A_per_meter BUnit=tesla curve (-2308000, 0) (-2307459.7, 0.037197189) (-2306906.7, 0.074038052) (-2306340.7, 0.11049806) (-2305761.6, 0.14655289) (-2305168.8, 0.18217844) (-2304562.2, 0.21735094) (-2303941.4, 0.25204701) (-2303306, 0.2862437) (-2302655.8, 0.31991857) (-2301990.4, 0.35304975) (-2301309.3, 0.38561602) (-2300612.4, 0.41759687) (-2299899.1, 0.44897257) (-2299169.1, 0.47972422) (-2298422, 0.50983383) (-2297657.4, 0.53928439) (-2296875, 0.5680599) (-2296074.2, 0.59614548) (-2295254.6, 0.62352737) (-2294415.9, 0.65019303) (-2293557.6, 0.67613115) (-2292679.1, 0.70133174) (-2291780.1, 0.72578614) (-2290860, 0.74948707) (-2289918.4, 0.77242868) (-2288954.8, 0.79460652) (-2287968.6, 0.81601764) (-2286959.3, 0.83666056) (-2285926.3, 0.85653528) (-2284869.2, 0.87564328) (-2283787.4, 0.89398757) (-2282680.2, 0.9115726) (-2281547.1, 0.92840431) (-2280387.4, 0.94449006) (-2279200.6, 0.95983864) (-2277986.1, 0.97446019) (-2276743.1, 0.98836619) (-2275471, 1.0015694) (-2274169.1, 1.0140838) (-2272836.7, 1.0259245) (-2271473.2, 1.0371077) (-2270077.7, 1.0476507) (-2268649.5, 1.0575715) (-2267187.9, 1.0668893) (-2265692.1, 1.0756237) (-2264161.3, 1.0837952) (-2262594.7, 1.0914248) (-2260991.3, 1.0985339) (-2259350.4, 1.1051444) (-2257671.2, 1.1112784) (-2255952.6, 1.1169582) (-2254193.7, 1.1222061) (-2252393.7, 1.1270446) (-2250551.5, 1.131496) (-2248666.3, 1.1355822) (-2246736.8, 1.139325) (-2244762.2, 1.1427459) (-2242741.4, 1.1458659) (-2240673.3, 1.1487054) (-2238556.7, 1.1512843) (-2236390.7, 1.1536218) (-2234173.8, 1.1557366) (-2231905.1, 1.1576463) (-2229583.3, 1.1593682) (-2227207.1, 1.1609183) (-2224775.3, 1.1623123) (-2222286.6, 1.1635646) (-2219739.6, 1.164689) (-2217132.9, 1.1656984) (-2214465.3, 1.1666048) (-2211735.2, 1.1674195) (-2208941.1, 1.1681527) (-2206081.7, 1.168814) (-2203155.3, 1.1694124) (-2200160.4, 1.1699557) (-2197095.4, 1.1704513) (-2193958.6, 1.170906) (-2190748.4, 1.1713255) (-2187463.1, 1.1717155) (-2184100.8, 1.1720806) (-2180659.8, 1.1724252) (-2177138.3, 1.1727531) (-2173534.3, 1.1730677) (-2169845.9, 1.1733719) (-2166071.2, 1.1736684) (-2162208.1, 1.1739594) (-2158254.6, 1.1742469) (-2154208.5, 1.1745326) (-2150067.7, 1.1748179) (-2145829.9, 1.1751043) (-2141493, 1.1753926) (-2137054.5, 1.175684) (-2132512, 1.1759792) (-2127863.3, 1.1762788) (-2123105.7, 1.1765836) (-2118236.7, 1.176894) (-2113253.8, 1.1772105) (-2108154.2, 1.1775335) (-2102935.1, 1.1778634) (-2097594, 1.1782005) (-2092127.7, 1.178545) (-2086533.5, 1.1788973) (-2080808.3, 1.1792576) (-2074949.1, 1.1796261) (-2068952.7, 1.1800032) (-2062816, 1.180389) (-2056535.5, 1.1807837) (-2050108.1, 1.1811877) (-2043530.1, 1.1816011) (-2036798.2, 1.1820241) (-2029908.6, 1.182457) (-2022857.8, 1.1829001) (-2015641.9, 1.1833535) (-2008257, 1.1838175) (-2000699.3, 1.1842923) (-1992964.6, 1.1847783) (-1985048.8, 1.1852757) (-1976947.8, 1.1857847) (-1968657, 1.1863056)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} conductivity=349253.28 magnetic_coercivity{Magnitude=-2308000A_per_meter DirComp1=1 DirComp2=0 DirComp3=0}

design PWM_Voltage (Maxwell 2D, Transient, XY geometry, model units mm)
options: ModelDepth=Magnetic_Axial_Length
variables:
  AAA = 1000
  DiaGap = 142.54mm
  DiaStatorYoke = 198mm
  DiaOuter = 198mm
  Airgap = 1mm
  StatorSkewAngle = 0deg
  Model_Length = 0mm
  Stator_Lam_Length = 0mm
  SlotNumber_Stator = 48
  SlotType_Stator = 3
  Hs0_Stator = 1mm
  Hs1_Stator = 0.28212317mm
  Hs2_Stator = 12.551463mm
  Bs0_Stator = 1.43mm
  Bs1_Stator = 4.63mm
  Bs2_Stator = 4.63mm
  Rs_Stator = 0mm
  FilletType_Stator = 1
  Magnetic_Axial_Length = 150mm
  Layers = 6
  ParallelPaths = 2
  WireWidth = 3.711mm
  WireThick = 1.686mm
  WireRad = 0.3mm
  LayerGap = 0.35mm
  SpanExt_F = 40.095067mm
  SpanExt_R = 32.973924mm
  DiaGap_Hairpin = 142.37546mm
  WdgExt_Avg = 5mm
  HalfAxial = 0
  SymmetryFactor = 8
  SegAngle = 0deg
  SegAngle_Coil_Armature = 10deg
  NumPoles = 8
  IPeak = 650.53824A
  PhaseAdvance = 43.33deg
  MachineRPM = 750rpm
  Vpeak = 0V
  MaxPhasorAngle = 120deg
  DriveOffsetED = 30deg
  InitialPositionMD = DriveOffsetED / (NumPoles/2)
  StatorFrequency = NumPoles/2*MachineRPM/1rpm/60*1Hz
  # PWM
  SwitchingFrequency = 10000
  BusDC = 698.4
  PhaseVoltagePeak = 100V
  phiV = -10deg
  PhaseVoltageAngle = phiV - 90*1deg
  StatorResistance = 0.01958ohm
  EndWindingInductance = 0.001868mH
  Tmin = 1e-06
  Tmax = 3e-06
  PeriodMultiplier = 2
geometry:
  Stator_2 [NO18-1160_180C_SF0.97] = user_primitive(RMxprt/VentSlotCore.dll, DiaGap=DiaGap, DiaYoke=DiaStatorYoke, Length=Stator_Lam_Length, Skew=StatorSkewAngle, Slots=SlotNumber_Stator, SlotType=SlotType_Stator, Hs0=Hs0_Stator, Hs01=0mm, Hs1=Hs1_Stator, Hs2=12.551463mm, Bs0=Bs0_Stator, Bs1=4.63mm, Bs2=4.63mm, Rs=Rs_Stator, FilletType=FilletType_Stator, HalfSlot=0, VentHoles=0, HoleDiaIn=0mm, HoleDiaOut=0mm, HoleLocIn=0mm, HoleLocOut=0mm, VentDucts=0, DuctWidth=0mm, DuctPitch=0mm, SegAngle=SegAngle, LenRegion=0mm, InfoCore=0)
  Rotor_1 [NO18-1160_140C_SF0.97] = circle(normal=Z, centre=(0mm, 0mm, 0mm), radius=70.27mm)
  Rotor_Subtract_10 = circle(normal=Z, centre=(0mm, 0mm, 0mm), radius=23.455mm)
  Rotor_1.subtract(Rotor_Subtract_10)
  Rotor_Pocket_9 [vacuum] = polyline(z=0mm, xy in mm: (45.5148, 22.4775) (46.0306, 21.021) (47.5588, 20.7927) (49.4755, 21.5866) (50.0589, 22.0183) (50.3714, 22.6734) (50.4107, 22.8664) (54.1907, 41.4458) (54.3596, 42.2762) (54.352, 42.7126) (54.1605, 43.1049) (53.2056, 44.2782) (52.2253, 45.4304) (51.8654, 45.6019) (51.4945, 45.4558) (50.6239, 44.5852) (50.4726, 44.4083) (50.3504, 44.2102) (49.7597, 43.0607) (49.6785, 42.8721) (49.6239, 42.6741) (49.5654, 42.3868) (45.6857, 23.3175) (45.5148, 22.4775), closed, covered, Arc from point 0 over 3, Arc from point 3 over 3, Arc from point 8 over 3, Arc from point 10 over 3, Arc from point 12 over 3, Arc from point 15 over 3, Arc from point 18 over 3)
  coordinate_system CS_L1_1Magnet2N1_1 = origin=(50.086083mm, 32.606724mm, 0mm) x=(1.1912749mm, -0.24236761mm, 0mm) y=(0.24236761mm, 1.1912749mm, 0mm)
  L1_1Magnet2N1_1 [N42EH_20C [ref. Temp]_2D3DFactMagnet, oriented by CS_L1_1Magnet2N1_1] = polyline(z=0mm, xy in mm: (53.8004, 42.0354) (50.3511, 42.7372) (49.9754, 42.6642) (49.7614, 42.3469) (45.9814, 23.7676) (46.0544, 23.3919) (46.3717, 23.1779) (49.821, 22.4761) (50.1967, 22.5492) (50.4107, 22.8664) (54.1907, 41.4458) (54.1177, 41.8214) (53.8004, 42.0354), closed, covered, Arc from point 1 over 3, Arc from point 4 over 3, Arc from point 7 over 3, Arc from point 10 over 3)
  Rotor_Pocket_17 [vacuum] = polyline(z=0mm, xy in mm: (48.7926, 15.8167) (65.0201, 5.076) (65.2645, 4.9142) (65.4432, 4.8128) (65.6339, 4.7368) (66.8645, 4.3417) (67.0909, 4.288) (67.323, 4.27) (68.5542, 4.27) (68.9198, 4.4289) (69.053, 4.8047) (68.9315, 6.3125) (68.7771, 7.8174) (68.6351, 8.2302) (68.3318, 8.5442) (67.6252, 9.0119) (51.8147, 19.4767) (51.6505, 19.5854) (50.9663, 19.8277) (50.2485, 19.7204) (48.3318, 18.9264) (47.4127, 17.6844) (48.0779, 16.2898) (48.7926, 15.8167), closed, covered, Arc from point 2 over 3, Arc from point 5 over 3, Arc from point 8 over 3, Arc from point 10 over 3, Arc from point 12 over 3, Arc from point 17 over 3, Arc from point 20 over 3)
  coordinate_system CS_L1_1Magnet1N1_1 = origin=(58.472644mm, 12.359773mm, 0mm) x=(0.67097875mm, 1.0137383mm, 0mm) y=(-1.0137383mm, 0.67097875mm, 0mm)
  L1_1Magnet1N1_1 [N42EH_20C [ref. Temp]_2D3DFactMagnet, oriented by CS_L1_1Magnet1N1_1] = polyline(z=0mm, xy in mm: (65.8234, 5.3838) (67.7662, 8.319) (67.8392, 8.6947) (67.6252, 9.0119) (51.8147, 19.4767) (51.4391, 19.5497) (51.1218, 19.3357) (49.179, 16.4004) (49.106, 16.0248) (49.32, 15.7075) (65.1305, 5.2428) (65.5061, 5.1698) (65.8234, 5.3838), closed, covered, Arc from point 1 over 3, Arc from point 4 over 3, Arc from point 7 over 3, Arc from point 10 over 3)
  Rotor_Pocket_23 [vacuum] = polyline(z=0mm, xy in mm: (55.8125, 36.4691) (55.8337, 36.2755) (55.8797, 36.0864) (55.9706, 35.7962) (59.0002, 26.1289) (59.625, 25.4146) (60.5737, 25.3935) (61.4274, 25.7471) (62.0006, 26.2953) (62.0535, 27.0867) (59.0242, 36.7531) (58.7793, 37.5344) (58.7399, 37.6359) (58.6873, 37.7312) (57.9666, 38.8293) (57.2254, 39.9136) (56.9069, 40.098) (56.561, 39.9723) (56.1634, 39.5747) (55.826, 39.0575) (55.7255, 38.4482) (55.8125, 36.4691), closed, covered, Arc from point 0 over 3, Arc from point 4 over 3, Arc from point 7 over 3, Arc from point 11 over 3, Arc from point 13 over 3, Arc from point 15 over 3, Arc from point 18 over 3)
  coordinate_system CS_L2_1Magnet2N1_1 = origin=(59.083666mm, 31.463921mm, 0mm) x=(1.1600509mm, 0.36353791mm, 0mm) y=(-0.36353791mm, 1.1600509mm, 0mm)
  L2_1Magnet2N1_1 [N42EH_20C [ref. Temp]_2D3DFactMagnet, oriented by CS_L2_1Magnet2N1_1] = polyline(z=0mm, xy in mm: (58.3975, 37.0807) (56.4414, 36.4677) (56.1478, 36.2222) (56.1138, 35.8411) (59.143, 26.1746) (59.3885, 25.881) (59.7697, 25.847) (61.7259, 26.46) (62.0195, 26.7055) (62.0535, 27.0867) (59.0242, 36.7531) (58.7787, 37.0467) (58.3975, 37.0807), closed, covered, Arc from point 1 over 3, Arc from point 4 over 3, Arc from point 7 over 3, Arc from point 10 over 3)
  Rotor_Pocket_31 [vacuum] = polyline(z=0mm, xy in mm: (64.889, 14.2654) (65.0298, 13.996) (65.131, 13.8296) (65.2529, 13.6778) (66.5909, 12.2169) (67.0928, 11.8571) (67.6971, 11.7299) (68.2594, 11.73) (68.5929, 11.8856) (68.6877, 12.2413) (68.4451, 13.5321) (68.1782, 14.8182) (68.148, 14.9227) (68.1041, 15.0224) (67.7248, 15.748) (63.0316, 24.7252) (62.4346, 25.2474) (61.6417, 25.2297) (60.788, 24.8761) (60.1321, 24.1903) (60.1954, 23.2434) (64.889, 14.2654), closed, covered, Arc from point 1 over 3, Arc from point 4 over 3, Arc from point 7 over 3, Arc from point 9 over 3, Arc from point 11 over 3, Arc from point 15 over 3, Arc from point 18 over 3)
  coordinate_system CS_L2_1Magnet1N1_1 = origin=(64.026812mm, 19.530109mm, 0mm) x=(1.07734mm, 0.56321972mm, 0mm) y=(-0.56321972mm, 1.07734mm, 0mm)
  L2_1Magnet1N1_1 [N42EH_20C [ref. Temp]_2D3DFactMagnet, oriented by CS_L2_1Magnet1N1_1] = polyline(z=0mm, xy in mm: (65.6966, 14.1235) (67.5134, 15.0732) (67.7588, 15.3668) (67.7248, 15.748) (63.0316, 24.7252) (62.738, 24.9707) (62.3569, 24.9367) (60.5402, 23.9869) (60.2947, 23.6933) (60.3287, 23.3122) (65.0219, 14.3349) (65.3155, 14.0894) (65.6966, 14.1235), closed, covered, Arc from point 1 over 3, Arc from point 4 over 3, Arc from point 7 over 3, Arc from point 10 over 3)
  Shaft [Stahl 37_80C_2D3DFactShaft] = circle(normal=Z, centre=(0mm, 0mm, 0mm), radius=23.455mm)
  Ph1_P1_C1_1 = user_primitive(RMxprt/HairpinCoil.dll, DiaGap=DiaGap_Hairpin, DiaYoke=DiaStatorYoke, Length=Stator_Lam_Length, Skew=StatorSkewAngle, Slots=SlotNumber_Stator, SlotType=SlotType_Stator, Hs0=Hs0_Stator, Hs1=Hs1_Stator, Hs2=Hs2_Stator, Bs0=Bs0_Stator, Bs1=Bs1_Stator, Bs2=Bs2_Stator, Rs=Rs_Stator, FilletType=1, Layers=Layers, CoilPitch=-6, EndExt=WdgExt_Avg, SpanExt/SpanGap=SpanExt_F, SegAngle=SegAngle_Coil_Armature, 1stPitch=0, 2ndPitch=6, 2ndSpanExt/SpanGap=SpanExt_R, WireWidth=WireWidth, WireThick=WireThick, WireRad=WireRad, LayerSetGap=LayerGap, LayerSetIdx=0, LayerGap=LayerGap, WindingType=1, CoilSetIdx=0, LenRegion=Model_Length, InfoCoil=4)
  Ph1_P1_C1_1.rotate(axis=Z, angle=45deg)
  Ph1_P1_C5_1 = user_primitive(RMxprt/HairpinCoil.dll, DiaGap=DiaGap_Hairpin, DiaYoke=DiaStatorYoke, Length=Stator_Lam_Length, Skew=StatorSkewAngle, Slots=SlotNumber_Stator, SlotType=SlotType_Stator, Hs0=Hs0_Stator, Hs1=Hs1_Stator, Hs2=Hs2_Stator, Bs0=Bs0_Stator, Bs1=Bs1_Stator, Bs2=Bs2_Stator, Rs=Rs_Stator, FilletType=1, Layers=Layers, CoilPitch=-6, EndExt=WdgExt_Avg, SpanExt/SpanGap=SpanExt_F, SegAngle=SegAngle_Coil_Armature, 1stPitch=0, 2ndPitch=6, 2ndSpanExt/SpanGap=SpanExt_R, WireWidth=WireWidth, WireThick=WireThick, WireRad=WireRad, LayerSetGap=LayerGap, LayerSetIdx=1, LayerGap=LayerGap, WindingType=1, CoilSetIdx=0, LenRegion=Model_Length, InfoCoil=4)
  Ph1_P1_C5_1.rotate(axis=Z, angle=52.5deg)
  Ph1_P1_C9_1 = user_primitive(RMxprt/HairpinCoil.dll, DiaGap=DiaGap_Hairpin, DiaYoke=DiaStatorYoke, Length=Stator_Lam_Length, Skew=StatorSkewAngle, Slots=SlotNumber_Stator, SlotType=SlotType_Stator, Hs0=Hs0_Stator, Hs1=Hs1_Stator, Hs2=Hs2_Stator, Bs0=Bs0_Stator, Bs1=Bs1_Stator, Bs2=Bs2_Stator, Rs=Rs_Stator, FilletType=1, Layers=Layers, CoilPitch=-6, EndExt=WdgExt_Avg, SpanExt/SpanGap=SpanExt_F, SegAngle=SegAngle_Coil_Armature, 1stPitch=0, 2ndPitch=6, 2ndSpanExt/SpanGap=SpanExt_R, WireWidth=WireWidth, WireThick=WireThick, WireRad=WireRad, LayerSetGap=LayerGap, LayerSetIdx=2, LayerGap=LayerGap, WindingType=1, CoilSetIdx=0, LenRegion=Model_Length, InfoCoil=4)
  Ph1_P1_C9_1.rotate(axis=Z, angle=45deg)
  Ph1_P1_C13_1 = user_primitive(RMxprt/HairpinCoil.dll, DiaGap=DiaGap_Hairpin, DiaYoke=DiaStatorYoke, Length=Stator_Lam_Length, Skew=StatorSkewAngle, Slots=SlotNumber_Stator, SlotType=SlotType_Stator, Hs0=Hs0_Stator, Hs1=Hs1_Stator, Hs2=Hs2_Stator, Bs0=Bs0_Stator, Bs1=Bs1_Stator, Bs2=Bs2_Stator, Rs=Rs_Stator, FilletType=1, Layers=Layers, CoilPitch=-6, EndExt=WdgExt_Avg, SpanExt/SpanGap=SpanExt_F, SegAngle=SegAngle_Coil_Armature, 1stPitch=0, 2ndPitch=6, 2ndSpanExt/SpanGap=SpanExt_R, WireWidth=WireWidth, WireThick=WireThick, WireRad=WireRad, LayerSetGap=LayerGap, LayerSetIdx=0, LayerGap=LayerGap, WindingType=1, CoilSetIdx=0, LenRegion=Model_Length, InfoCoil=4)
  Ph1_P1_C13_1.rotate(axis=Z, angle=52.5deg)
  Ph1_P1_C17_1 = user_primitive(RMxprt/HairpinCoil.dll, DiaGap=DiaGap_Hairpin, DiaYoke=DiaStatorYoke, Length=Stator_Lam_Length, Skew=StatorSkewAngle, Slots=SlotNumber_Stator, SlotType=SlotType_Stator, Hs0=Hs0_Stator, Hs1=Hs1_Stator, Hs2=Hs2_Stator, Bs0=Bs0_Stator, Bs1=Bs1_Stator, Bs2=Bs2_Stator, Rs=Rs_Stator, FilletType=1, Layers=Layers, CoilPitch=-6, EndExt=WdgExt_Avg, SpanExt/SpanGap=SpanExt_F, SegAngle=SegAngle_Coil_Armature, 1stPitch=0, 2ndPitch=6, 2ndSpanExt/SpanGap=SpanExt_R, WireWidth=WireWidth, WireThick=WireThick, WireRad=WireRad, LayerSetGap=LayerGap, LayerSetIdx=1, LayerGap=LayerGap, WindingType=1, CoilSetIdx=0, LenRegion=Model_Length, InfoCoil=4)
  Ph1_P1_C17_1.rotate(axis=Z, angle=45deg)
  Ph1_P1_C21_1 = user_primitive(RMxprt/HairpinCoil.dll, DiaGap=DiaGap_Hairpin, DiaYoke=DiaStatorYoke, Length=Stator_Lam_Length, Skew=StatorSkewAngle, Slots=SlotNumber_Stator, SlotType=SlotType_Stator, Hs0=Hs0_Stator, Hs1=Hs1_Stator, Hs2=Hs2_Stator, Bs0=Bs0_Stator, Bs1=Bs1_Stator, Bs2=Bs2_Stator, Rs=Rs_Stator, FilletType=1, Layers=Layers, CoilPitch=-6, EndExt=WdgExt_Avg, SpanExt/SpanGap=SpanExt_F, SegAngle=SegAngle_Coil_Armature, 1stPitch=0, 2ndPitch=6, 2ndSpanExt/SpanGap=SpanExt_R, WireWidth=WireWidth, WireThick=WireThick, WireRad=WireRad, LayerSetGap=LayerGap, LayerSetIdx=2, LayerGap=LayerGap, WindingType=1, CoilSetIdx=0, LenRegion=Model_Length, InfoCoil=4)
  Ph1_P1_C21_1.rotate(axis=Z, angle=52.5deg)
  Ph1_P2_C1_1 [Copper (Pure)_20C [ref. Temp]] = user_primitive(RMxprt/HairpinCoil.dll, DiaGap=DiaGap_Hairpin, DiaYoke=DiaStatorYoke, Length=Stator_Lam_Length, Skew=StatorSkewAngle, Slots=SlotNumber_Stator, SlotType=SlotType_Stator, Hs0=Hs0_Stator, Hs1=Hs1_Stator, Hs2=Hs2_Stator, Bs0=Bs0_Stator, Bs1=Bs1_Stator, Bs2=Bs2_Stator, Rs=Rs_Stator, FilletType=1, Layers=Layers, CoilPitch=-6, EndExt=WdgExt_Avg, SpanExt/SpanGap=SpanExt_F, SegAngle=SegAngle_Coil_Armature, 1stPitch=0, 2ndPitch=6, 2ndSpanExt/SpanGap=SpanExt_R, WireWidth=WireWidth, WireThick=WireThick, WireRad=WireRad, LayerSetGap=LayerGap, LayerSetIdx=0, LayerGap=LayerGap, WindingType=1, CoilSetIdx=0, LenRegion=Model_Length, InfoCoil=4)
  Ph1_P2_C1_1.rotate(axis=Z, angle=0deg)
  Ph1_P2_C5_1 [Copper (Pure)_20C [ref. Temp]] = user_primitive(RMxprt/HairpinCoil.dll, DiaGap=DiaGap_Hairpin, DiaYoke=DiaStatorYoke, Length=Stator_Lam_Length, Skew=StatorSkewAngle, Slots=SlotNumber_Stator, SlotType=SlotType_Stator, Hs0=Hs0_Stator, Hs1=Hs1_Stator, Hs2=Hs2_Stator, Bs0=Bs0_Stator, Bs1=Bs1_Stator, Bs2=Bs2_Stator, Rs=Rs_Stator, FilletType=1, Layers=Layers, CoilPitch=-6, EndExt=WdgExt_Avg, SpanExt/SpanGap=SpanExt_F, SegAngle=SegAngle_Coil_Armature, 1stPitch=0, 2ndPitch=6, 2ndSpanExt/SpanGap=SpanExt_R, WireWidth=WireWidth, WireThick=WireThick, WireRad=WireRad, LayerSetGap=LayerGap, LayerSetIdx=1, LayerGap=LayerGap, WindingType=1, CoilSetIdx=0, LenRegion=Model_Length, InfoCoil=4)
  Ph1_P2_C5_1.rotate(axis=Z, angle=7.5deg)
  Ph1_P2_C9_1 [Copper (Pure)_20C [ref. Temp]] = user_primitive(RMxprt/HairpinCoil.dll, DiaGap=DiaGap_Hairpin, DiaYoke=DiaStatorYoke, Length=Stator_Lam_Length, Skew=StatorSkewAngle, Slots=SlotNumber_Stator, SlotType=SlotType_Stator, Hs0=Hs0_Stator, Hs1=Hs1_Stator, Hs2=Hs2_Stator, Bs0=Bs0_Stator, Bs1=Bs1_Stator, Bs2=Bs2_Stator, Rs=Rs_Stator, FilletType=1, Layers=Layers, CoilPitch=-6, EndExt=WdgExt_Avg, SpanExt/SpanGap=SpanExt_F, SegAngle=SegAngle_Coil_Armature, 1stPitch=0, 2ndPitch=6, 2ndSpanExt/SpanGap=SpanExt_R, WireWidth=WireWidth, WireThick=WireThick, WireRad=WireRad, LayerSetGap=LayerGap, LayerSetIdx=2, LayerGap=LayerGap, WindingType=1, CoilSetIdx=0, LenRegion=Model_Length, InfoCoil=4)
  Ph1_P2_C9_1.rotate(axis=Z, angle=0deg)
  Ph1_P2_C13_1 [Copper (Pure)_20C [ref. Temp]] = user_primitive(RMxprt/HairpinCoil.dll, DiaGap=DiaGap_Hairpin, DiaYoke=DiaStatorYoke, Length=Stator_Lam_Length, Skew=StatorSkewAngle, Slots=SlotNumber_Stator, SlotType=SlotType_Stator, Hs0=Hs0_Stator, Hs1=Hs1_Stator, Hs2=Hs2_Stator, Bs0=Bs0_Stator, Bs1=Bs1_Stator, Bs2=Bs2_Stator, Rs=Rs_Stator, FilletType=1, Layers=Layers, CoilPitch=-6, EndExt=WdgExt_Avg, SpanExt/SpanGap=SpanExt_F, SegAngle=SegAngle_Coil_Armature, 1stPitch=0, 2ndPitch=6, 2ndSpanExt/SpanGap=SpanExt_R, WireWidth=WireWidth, WireThick=WireThick, WireRad=WireRad, LayerSetGap=LayerGap, LayerSetIdx=0, LayerGap=LayerGap, WindingType=1, CoilSetIdx=0, LenRegion=Model_Length, InfoCoil=4)
  Ph1_P2_C13_1.rotate(axis=Z, angle=7.5deg)
  Ph1_P2_C17_1 [Copper (Pure)_20C [ref. Temp]] = user_primitive(RMxprt/HairpinCoil.dll, DiaGap=DiaGap_Hairpin, DiaYoke=DiaStatorYoke, Length=Stator_Lam_Length, Skew=StatorSkewAngle, Slots=SlotNumber_Stator, SlotType=SlotType_Stator, Hs0=Hs0_Stator, Hs1=Hs1_Stator, Hs2=Hs2_Stator, Bs0=Bs0_Stator, Bs1=Bs1_Stator, Bs2=Bs2_Stator, Rs=Rs_Stator, FilletType=1, Layers=Layers, CoilPitch=-6, EndExt=WdgExt_Avg, SpanExt/SpanGap=SpanExt_F, SegAngle=SegAngle_Coil_Armature, 1stPitch=0, 2ndPitch=6, 2ndSpanExt/SpanGap=SpanExt_R, WireWidth=WireWidth, WireThick=WireThick, WireRad=WireRad, LayerSetGap=LayerGap, LayerSetIdx=1, LayerGap=LayerGap, WindingType=1, CoilSetIdx=0, LenRegion=Model_Length, InfoCoil=4)
  Ph1_P2_C17_1.rotate(axis=Z, angle=0deg)
  Ph1_P2_C21_1 [Copper (Pure)_20C [ref. Temp]] = user_primitive(RMxprt/HairpinCoil.dll, DiaGap=DiaGap_Hairpin, DiaYoke=DiaStatorYoke, Length=Stator_Lam_Length, Skew=StatorSkewAngle, Slots=SlotNumber_Stator, SlotType=SlotType_Stator, Hs0=Hs0_Stator, Hs1=Hs1_Stator, Hs2=Hs2_Stator, Bs0=Bs0_Stator, Bs1=Bs1_Stator, Bs2=Bs2_Stator, Rs=Rs_Stator, FilletType=1, Layers=Layers, CoilPitch=-6, EndExt=WdgExt_Avg, SpanExt/SpanGap=SpanExt_F, SegAngle=SegAngle_Coil_Armature, 1stPitch=0, 2ndPitch=6, 2ndSpanExt/SpanGap=SpanExt_R, WireWidth=WireWidth, WireThick=WireThick, WireRad=WireRad, LayerSetGap=LayerGap, LayerSetIdx=2, LayerGap=LayerGap, WindingType=1, CoilSetIdx=0, LenRegion=Model_Length, InfoCoil=4)
  Ph1_P2_C21_1.rotate(axis=Z, angle=7.5deg)
  Ph2_P1_C4_1 = user_primitive(RMxprt/HairpinCoil.dll, DiaGap=DiaGap_Hairpin, DiaYoke=DiaStatorYoke, Length=Stator_Lam_Length, Skew=StatorSkewAngle, Slots=SlotNumber_Stator, SlotType=SlotType_Stator, Hs0=Hs0_Stator, Hs1=Hs1_Stator, Hs2=Hs2_Stator, Bs0=Bs0_Stator, Bs1=Bs1_Stator, Bs2=Bs2_Stator, Rs=Rs_Stator, FilletType=1, Layers=Layers, CoilPitch=-6, EndExt=WdgExt_Avg, SpanExt/SpanGap=SpanExt_F, SegAngle=SegAngle_Coil_Armature, 1stPitch=0, 2ndPitch=6, 2ndSpanExt/SpanGap=SpanExt_R, WireWidth=WireWidth, WireThick=WireThick, WireRad=WireRad, LayerSetGap=LayerGap, LayerSetIdx=0, LayerGap=LayerGap, WindingType=1, CoilSetIdx=0, LenRegion=Model_Length, InfoCoil=4)
  Ph2_P1_C4_1.rotate(axis=Z, angle=75deg)
  Ph2_P1_C8_1 = user_primitive(RMxprt/HairpinCoil.dll, DiaGap=DiaGap_Hairpin, DiaYoke=DiaStatorYoke, Length=Stator_Lam_Length, Skew=StatorSkewAngle, Slots=SlotNumber_Stator, SlotType=SlotType_Stator, Hs0=Hs0_Stator, Hs1=Hs1_Stator, Hs2=Hs2_Stator, Bs0=Bs0_Stator, Bs1=Bs1_Stator, Bs2=Bs2_Stator, Rs=Rs_Stator, FilletType=1, Layers=Layers, CoilPitch=-6, EndExt=WdgExt_Avg, SpanExt/SpanGap=SpanExt_F, SegAngle=SegAngle_Coil_Armature, 1stPitch=0, 2ndPitch=6, 2ndSpanExt/SpanGap=SpanExt_R, WireWidth=WireWidth, WireThick=WireThick, WireRad=WireRad, LayerSetGap=LayerGap, LayerSetIdx=1, LayerGap=LayerGap, WindingType=1, CoilSetIdx=0, LenRegion=Model_Length, InfoCoil=4)
  Ph2_P1_C8_1.rotate(axis=Z, angle=82.5deg)
  Ph2_P1_C12_1 = user_primitive(RMxprt/HairpinCoil.dll, DiaGap=DiaGap_Hairpin, DiaYoke=DiaStatorYoke, Length=Stator_Lam_Length, Skew=StatorSkewAngle, Slots=SlotNumber_Stator, SlotType=SlotType_Stator, Hs0=Hs0_Stator, Hs1=Hs1_Stator, Hs2=Hs2_Stator, Bs0=Bs0_Stator, Bs1=Bs1_Stator, Bs2=Bs2_Stator, Rs=Rs_Stator, FilletType=1, Layers=Layers, CoilPitch=-6, EndExt=WdgExt_Avg, SpanExt/SpanGap=SpanExt_F, SegAngle=SegAngle_Coil_Armature, 1stPitch=0, 2ndPitch=6, 2ndSpanExt/SpanGap=SpanExt_R, WireWidth=WireWidth, WireThick=WireThick, WireRad=WireRad, LayerSetGap=LayerGap, LayerSetIdx=2, LayerGap=LayerGap, WindingType=1, CoilSetIdx=0, LenRegion=Model_Length, InfoCoil=4)
  Ph2_P1_C12_1.rotate(axis=Z, angle=75deg)
  Ph2_P1_C16_1 = user_primitive(RMxprt/HairpinCoil.dll, DiaGap=DiaGap_Hairpin, DiaYoke=DiaStatorYoke, Length=Stator_Lam_Length, Skew=StatorSkewAngle, Slots=SlotNumber_Stator, SlotType=SlotType_Stator, Hs0=Hs0_Stator, Hs1=Hs1_Stator, Hs2=Hs2_Stator, Bs0=Bs0_Stator, Bs1=Bs1_Stator, Bs2=Bs2_Stator, Rs=Rs_Stator, FilletType=1, Layers=Layers, CoilPitch=-6, EndExt=WdgExt_Avg, SpanExt/SpanGap=SpanExt_F, SegAngle=SegAngle_Coil_Armature, 1stPitch=0, 2ndPitch=6, 2ndSpanExt/SpanGap=SpanExt_R, WireWidth=WireWidth, WireThick=WireThick, WireRad=WireRad, LayerSetGap=LayerGap, LayerSetIdx=0, LayerGap=LayerGap, WindingType=1, CoilSetIdx=0, LenRegion=Model_Length, InfoCoil=4)
  Ph2_P1_C16_1.rotate(axis=Z, angle=82.5deg)
  Ph2_P1_C20_1 = user_primitive(RMxprt/HairpinCoil.dll, DiaGap=DiaGap_Hairpin, DiaYoke=DiaStatorYoke, Length=Stator_Lam_Length, Skew=StatorSkewAngle, Slots=SlotNumber_Stator, SlotType=SlotType_Stator, Hs0=Hs0_Stator, Hs1=Hs1_Stator, Hs2=Hs2_Stator, Bs0=Bs0_Stator, Bs1=Bs1_Stator, Bs2=Bs2_Stator, Rs=Rs_Stator, FilletType=1, Layers=Layers, CoilPitch=-6, EndExt=WdgExt_Avg, SpanExt/SpanGap=SpanExt_F, SegAngle=SegAngle_Coil_Armature, 1stPitch=0, 2ndPitch=6, 2ndSpanExt/SpanGap=SpanExt_R, WireWidth=WireWidth, WireThick=WireThick, WireRad=WireRad, LayerSetGap=LayerGap, LayerSetIdx=1, LayerGap=LayerGap, WindingType=1, CoilSetIdx=0, LenRegion=Model_Length, InfoCoil=4)
  Ph2_P1_C20_1.rotate(axis=Z, angle=75deg)
  Ph2_P1_C24_1 = user_primitive(RMxprt/HairpinCoil.dll, DiaGap=DiaGap_Hairpin, DiaYoke=DiaStatorYoke, Length=Stator_Lam_Length, Skew=StatorSkewAngle, Slots=SlotNumber_Stator, SlotType=SlotType_Stator, Hs0=Hs0_Stator, Hs1=Hs1_Stator, Hs2=Hs2_Stator, Bs0=Bs0_Stator, Bs1=Bs1_Stator, Bs2=Bs2_Stator, Rs=Rs_Stator, FilletType=1, Layers=Layers, CoilPitch=-6, EndExt=WdgExt_Avg, SpanExt/SpanGap=SpanExt_F, SegAngle=SegAngle_Coil_Armature, 1stPitch=0, 2ndPitch=6, 2ndSpanExt/SpanGap=SpanExt_R, WireWidth=WireWidth, WireThick=WireThick, WireRad=WireRad, LayerSetGap=LayerGap, LayerSetIdx=2, LayerGap=LayerGap, WindingType=1, CoilSetIdx=0, LenRegion=Model_Length, InfoCoil=4)
  Ph2_P1_C24_1.rotate(axis=Z, angle=82.5deg)
  Ph2_P2_C2_1 [Copper (Pure)_20C [ref. Temp]] = user_primitive(RMxprt/HairpinCoil.dll, DiaGap=DiaGap_Hairpin, DiaYoke=DiaStatorYoke, Length=Stator_Lam_Length, Skew=StatorSkewAngle, Slots=SlotNumber_Stator, SlotType=SlotType_Stator, Hs0=Hs0_Stator, Hs1=Hs1_Stator, Hs2=Hs2_Stator, Bs0=Bs0_Stator, Bs1=Bs1_Stator, Bs2=Bs2_Stator, Rs=Rs_Stator, FilletType=1, Layers=Layers, CoilPitch=-6, EndExt=WdgExt_Avg, SpanExt/SpanGap=SpanExt_F, SegAngle=SegAngle_Coil_Armature, 1stPitch=0, 2ndPitch=6, 2ndSpanExt/SpanGap=SpanExt_R, WireWidth=WireWidth, WireThick=WireThick, WireRad=WireRad, LayerSetGap=LayerGap, LayerSetIdx=0, LayerGap=LayerGap, WindingType=1, CoilSetIdx=0, LenRegion=Model_Length, InfoCoil=4)
  Ph2_P2_C2_1.rotate(axis=Z, angle=30deg)
  Ph2_P2_C6_1 [Copper (Pure)_20C [ref. Temp]] = user_primitive(RMxprt/HairpinCoil.dll, DiaGap=DiaGap_Hairpin, DiaYoke=DiaStatorYoke, Length=Stator_Lam_Length, Skew=StatorSkewAngle, Slots=SlotNumber_Stator, SlotType=SlotType_Stator, Hs0=Hs0_Stator, Hs1=Hs1_Stator, Hs2=Hs2_Stator, Bs0=Bs0_Stator, Bs1=Bs1_Stator, Bs2=Bs2_Stator, Rs=Rs_Stator, FilletType=1, Layers=Layers, CoilPitch=-6, EndExt=WdgExt_Avg, SpanExt/SpanGap=SpanExt_F, SegAngle=SegAngle_Coil_Armature, 1stPitch=0, 2ndPitch=6, 2ndSpanExt/SpanGap=SpanExt_R, WireWidth=WireWidth, WireThick=WireThick, WireRad=WireRad, LayerSetGap=LayerGap, LayerSetIdx=1, LayerGap=LayerGap, WindingType=1, CoilSetIdx=0, LenRegion=Model_Length, InfoCoil=4)
  Ph2_P2_C6_1.rotate(axis=Z, angle=37.5deg)
  Ph2_P2_C10_1 [Copper (Pure)_20C [ref. Temp]] = user_primitive(RMxprt/HairpinCoil.dll, DiaGap=DiaGap_Hairpin, DiaYoke=DiaStatorYoke, Length=Stator_Lam_Length, Skew=StatorSkewAngle, Slots=SlotNumber_Stator, SlotType=SlotType_Stator, Hs0=Hs0_Stator, Hs1=Hs1_Stator, Hs2=Hs2_Stator, Bs0=Bs0_Stator, Bs1=Bs1_Stator, Bs2=Bs2_Stator, Rs=Rs_Stator, FilletType=1, Layers=Layers, CoilPitch=-6, EndExt=WdgExt_Avg, SpanExt/SpanGap=SpanExt_F, SegAngle=SegAngle_Coil_Armature, 1stPitch=0, 2ndPitch=6, 2ndSpanExt/SpanGap=SpanExt_R, WireWidth=WireWidth, WireThick=WireThick, WireRad=WireRad, LayerSetGap=LayerGap, LayerSetIdx=2, LayerGap=LayerGap, WindingType=1, CoilSetIdx=0, LenRegion=Model_Length, InfoCoil=4)
  Ph2_P2_C10_1.rotate(axis=Z, angle=30deg)
  Ph2_P2_C14_1 [Copper (Pure)_20C [ref. Temp]] = user_primitive(RMxprt/HairpinCoil.dll, DiaGap=DiaGap_Hairpin, DiaYoke=DiaStatorYoke, Length=Stator_Lam_Length, Skew=StatorSkewAngle, Slots=SlotNumber_Stator, SlotType=SlotType_Stator, Hs0=Hs0_Stator, Hs1=Hs1_Stator, Hs2=Hs2_Stator, Bs0=Bs0_Stator, Bs1=Bs1_Stator, Bs2=Bs2_Stator, Rs=Rs_Stator, FilletType=1, Layers=Layers, CoilPitch=-6, EndExt=WdgExt_Avg, SpanExt/SpanGap=SpanExt_F, SegAngle=SegAngle_Coil_Armature, 1stPitch=0, 2ndPitch=6, 2ndSpanExt/SpanGap=SpanExt_R, WireWidth=WireWidth, WireThick=WireThick, WireRad=WireRad, LayerSetGap=LayerGap, LayerSetIdx=0, LayerGap=LayerGap, WindingType=1, CoilSetIdx=0, LenRegion=Model_Length, InfoCoil=4)
  Ph2_P2_C14_1.rotate(axis=Z, angle=37.5deg)
  Ph2_P2_C18_1 [Copper (Pure)_20C [ref. Temp]] = user_primitive(RMxprt/HairpinCoil.dll, DiaGap=DiaGap_Hairpin, DiaYoke=DiaStatorYoke, Length=Stator_Lam_Length, Skew=StatorSkewAngle, Slots=SlotNumber_Stator, SlotType=SlotType_Stator, Hs0=Hs0_Stator, Hs1=Hs1_Stator, Hs2=Hs2_Stator, Bs0=Bs0_Stator, Bs1=Bs1_Stator, Bs2=Bs2_Stator, Rs=Rs_Stator, FilletType=1, Layers=Layers, CoilPitch=-6, EndExt=WdgExt_Avg, SpanExt/SpanGap=SpanExt_F, SegAngle=SegAngle_Coil_Armature, 1stPitch=0, 2ndPitch=6, 2ndSpanExt/SpanGap=SpanExt_R, WireWidth=WireWidth, WireThick=WireThick, WireRad=WireRad, LayerSetGap=LayerGap, LayerSetIdx=1, LayerGap=LayerGap, WindingType=1, CoilSetIdx=0, LenRegion=Model_Length, InfoCoil=4)
  Ph2_P2_C18_1.rotate(axis=Z, angle=30deg)
  Ph2_P2_C22_1 [Copper (Pure)_20C [ref. Temp]] = user_primitive(RMxprt/HairpinCoil.dll, DiaGap=DiaGap_Hairpin, DiaYoke=DiaStatorYoke, Length=Stator_Lam_Length, Skew=StatorSkewAngle, Slots=SlotNumber_Stator, SlotType=SlotType_Stator, Hs0=Hs0_Stator, Hs1=Hs1_Stator, Hs2=Hs2_Stator, Bs0=Bs0_Stator, Bs1=Bs1_Stator, Bs2=Bs2_Stator, Rs=Rs_Stator, FilletType=1, Layers=Layers, CoilPitch=-6, EndExt=WdgExt_Avg, SpanExt/SpanGap=SpanExt_F, SegAngle=SegAngle_Coil_Armature, 1stPitch=0, 2ndPitch=6, 2ndSpanExt/SpanGap=SpanExt_R, WireWidth=WireWidth, WireThick=WireThick, WireRad=WireRad, LayerSetGap=LayerGap, LayerSetIdx=2, LayerGap=LayerGap, WindingType=1, CoilSetIdx=0, LenRegion=Model_Length, InfoCoil=4)
  Ph2_P2_C22_1.rotate(axis=Z, angle=37.5deg)
  Ph3_P1_C2_1 [Copper (Pure)_20C [ref. Temp]] = user_primitive(RMxprt/HairpinCoil.dll, DiaGap=DiaGap_Hairpin, DiaYoke=DiaStatorYoke, Length=Stator_Lam_Length, Skew=StatorSkewAngle, Slots=SlotNumber_Stator, SlotType=SlotType_Stator, Hs0=Hs0_Stator, Hs1=Hs1_Stator, Hs2=Hs2_Stator, Bs0=Bs0_Stator, Bs1=Bs1_Stator, Bs2=Bs2_Stator, Rs=Rs_Stator, FilletType=1, Layers=Layers, CoilPitch=-6, EndExt=WdgExt_Avg, SpanExt/SpanGap=SpanExt_F, SegAngle=SegAngle_Coil_Armature, 1stPitch=0, 2ndPitch=6, 2ndSpanExt/SpanGap=SpanExt_R, WireWidth=WireWidth, WireThick=WireThick, WireRad=WireRad, LayerSetGap=LayerGap, LayerSetIdx=0, LayerGap=LayerGap, WindingType=1, CoilSetIdx=0, LenRegion=Model_Length, InfoCoil=4)
  Ph3_P1_C2_1.rotate(axis=Z, angle=15deg)
  Ph3_P1_C6_1 [Copper (Pure)_20C [ref. Temp]] = user_primitive(RMxprt/HairpinCoil.dll, DiaGap=DiaGap_Hairpin, DiaYoke=DiaStatorYoke, Length=Stator_Lam_Length, Skew=StatorSkewAngle, Slots=SlotNumber_Stator, SlotType=SlotType_Stator, Hs0=Hs0_Stator, Hs1=Hs1_Stator, Hs2=Hs2_Stator, Bs0=Bs0_Stator, Bs1=Bs1_Stator, Bs2=Bs2_Stator, Rs=Rs_Stator, FilletType=1, Layers=Layers, CoilPitch=-6, EndExt=WdgExt_Avg, SpanExt/SpanGap=SpanExt_F, SegAngle=SegAngle_Coil_Armature, 1stPitch=0, 2ndPitch=6, 2ndSpanExt/SpanGap=SpanExt_R, WireWidth=WireWidth, WireThick=WireThick, WireRad=WireRad, LayerSetGap=LayerGap, LayerSetIdx=1, LayerGap=LayerGap, WindingType=1, CoilSetIdx=0, LenRegion=Model_Length, InfoCoil=4)
  Ph3_P1_C6_1.rotate(axis=Z, angle=22.5deg)
  Ph3_P1_C10_1 [Copper (Pure)_20C [ref. Temp]] = user_primitive(RMxprt/HairpinCoil.dll, DiaGap=DiaGap_Hairpin, DiaYoke=DiaStatorYoke, Length=Stator_Lam_Length, Skew=StatorSkewAngle, Slots=SlotNumber_Stator, SlotType=SlotType_Stator, Hs0=Hs0_Stator, Hs1=Hs1_Stator, Hs2=Hs2_Stator, Bs0=Bs0_Stator, Bs1=Bs1_Stator, Bs2=Bs2_Stator, Rs=Rs_Stator, FilletType=1, Layers=Layers, CoilPitch=-6, EndExt=WdgExt_Avg, SpanExt/SpanGap=SpanExt_F, SegAngle=SegAngle_Coil_Armature, 1stPitch=0, 2ndPitch=6, 2ndSpanExt/SpanGap=SpanExt_R, WireWidth=WireWidth, WireThick=WireThick, WireRad=WireRad, LayerSetGap=LayerGap, LayerSetIdx=2, LayerGap=LayerGap, WindingType=1, CoilSetIdx=0, LenRegion=Model_Length, InfoCoil=4)
  Ph3_P1_C10_1.rotate(axis=Z, angle=15deg)
  Ph3_P1_C14_1 [Copper (Pure)_20C [ref. Temp]] = user_primitive(RMxprt/HairpinCoil.dll, DiaGap=DiaGap_Hairpin, DiaYoke=DiaStatorYoke, Length=Stator_Lam_Length, Skew=StatorSkewAngle, Slots=SlotNumber_Stator, SlotType=SlotType_Stator, Hs0=Hs0_Stator, Hs1=Hs1_Stator, Hs2=Hs2_Stator, Bs0=Bs0_Stator, Bs1=Bs1_Stator, Bs2=Bs2_Stator, Rs=Rs_Stator, FilletType=1, Layers=Layers, CoilPitch=-6, EndExt=WdgExt_Avg, SpanExt/SpanGap=SpanExt_F, SegAngle=SegAngle_Coil_Armature, 1stPitch=0, 2ndPitch=6, 2ndSpanExt/SpanGap=SpanExt_R, WireWidth=WireWidth, WireThick=WireThick, WireRad=WireRad, LayerSetGap=LayerGap, LayerSetIdx=0, LayerGap=LayerGap, WindingType=1, CoilSetIdx=0, LenRegion=Model_Length, InfoCoil=4)
  Ph3_P1_C14_1.rotate(axis=Z, angle=22.5deg)
  Ph3_P1_C18_1 [Copper (Pure)_20C [ref. Temp]] = user_primitive(RMxprt/HairpinCoil.dll, DiaGap=DiaGap_Hairpin, DiaYoke=DiaStatorYoke, Length=Stator_Lam_Length, Skew=StatorSkewAngle, Slots=SlotNumber_Stator, SlotType=SlotType_Stator, Hs0=Hs0_Stator, Hs1=Hs1_Stator, Hs2=Hs2_Stator, Bs0=Bs0_Stator, Bs1=Bs1_Stator, Bs2=Bs2_Stator, Rs=Rs_Stator, FilletType=1, Layers=Layers, CoilPitch=-6, EndExt=WdgExt_Avg, SpanExt/SpanGap=SpanExt_F, SegAngle=SegAngle_Coil_Armature, 1stPitch=0, 2ndPitch=6, 2ndSpanExt/SpanGap=SpanExt_R, WireWidth=WireWidth, WireThick=WireThick, WireRad=WireRad, LayerSetGap=LayerGap, LayerSetIdx=1, LayerGap=LayerGap, WindingType=1, CoilSetIdx=0, LenRegion=Model_Length, InfoCoil=4)
  Ph3_P1_C18_1.rotate(axis=Z, angle=15deg)
  Ph3_P1_C22_1 [Copper (Pure)_20C [ref. Temp]] = user_primitive(RMxprt/HairpinCoil.dll, DiaGap=DiaGap_Hairpin, DiaYoke=DiaStatorYoke, Length=Stator_Lam_Length, Skew=StatorSkewAngle, Slots=SlotNumber_Stator, SlotType=SlotType_Stator, Hs0=Hs0_Stator, Hs1=Hs1_Stator, Hs2=Hs2_Stator, Bs0=Bs0_Stator, Bs1=Bs1_Stator, Bs2=Bs2_Stator, Rs=Rs_Stator, FilletType=1, Layers=Layers, CoilPitch=-6, EndExt=WdgExt_Avg, SpanExt/SpanGap=SpanExt_F, SegAngle=SegAngle_Coil_Armature, 1stPitch=0, 2ndPitch=6, 2ndSpanExt/SpanGap=SpanExt_R, WireWidth=WireWidth, WireThick=WireThick, WireRad=WireRad, LayerSetGap=LayerGap, LayerSetIdx=2, LayerGap=LayerGap, WindingType=1, CoilSetIdx=0, LenRegion=Model_Length, InfoCoil=4)
  Ph3_P1_C22_1.rotate(axis=Z, angle=22.5deg)
  Ph3_P2_C3_1 = user_primitive(RMxprt/HairpinCoil.dll, DiaGap=DiaGap_Hairpin, DiaYoke=DiaStatorYoke, Length=Stator_Lam_Length, Skew=StatorSkewAngle, Slots=SlotNumber_Stator, SlotType=SlotType_Stator, Hs0=Hs0_Stator, Hs1=Hs1_Stator, Hs2=Hs2_Stator, Bs0=Bs0_Stator, Bs1=Bs1_Stator, Bs2=Bs2_Stator, Rs=Rs_Stator, FilletType=1, Layers=Layers, CoilPitch=-6, EndExt=WdgExt_Avg, SpanExt/SpanGap=SpanExt_F, SegAngle=SegAngle_Coil_Armature, 1stPitch=0, 2ndPitch=6, 2ndSpanExt/SpanGap=SpanExt_R, WireWidth=WireWidth, WireThick=WireThick, WireRad=WireRad, LayerSetGap=LayerGap, LayerSetIdx=0, LayerGap=LayerGap, WindingType=1, CoilSetIdx=0, LenRegion=Model_Length, InfoCoil=4)
  Ph3_P2_C3_1.rotate(axis=Z, angle=60deg)
  Ph3_P2_C7_1 = user_primitive(RMxprt/HairpinCoil.dll, DiaGap=DiaGap_Hairpin, DiaYoke=DiaStatorYoke, Length=Stator_Lam_Length, Skew=StatorSkewAngle, Slots=SlotNumber_Stator, SlotType=SlotType_Stator, Hs0=Hs0_Stator, Hs1=Hs1_Stator, Hs2=Hs2_Stator, Bs0=Bs0_Stator, Bs1=Bs1_Stator, Bs2=Bs2_Stator, Rs=Rs_Stator, FilletType=1, Layers=Layers, CoilPitch=-6, EndExt=WdgExt_Avg, SpanExt/SpanGap=SpanExt_F, SegAngle=SegAngle_Coil_Armature, 1stPitch=0, 2ndPitch=6, 2ndSpanExt/SpanGap=SpanExt_R, WireWidth=WireWidth, WireThick=WireThick, WireRad=WireRad, LayerSetGap=LayerGap, LayerSetIdx=1, LayerGap=LayerGap, WindingType=1, CoilSetIdx=0, LenRegion=Model_Length, InfoCoil=4)
  Ph3_P2_C7_1.rotate(axis=Z, angle=67.5deg)
  Ph3_P2_C11_1 = user_primitive(RMxprt/HairpinCoil.dll, DiaGap=DiaGap_Hairpin, DiaYoke=DiaStatorYoke, Length=Stator_Lam_Length, Skew=StatorSkewAngle, Slots=SlotNumber_Stator, SlotType=SlotType_Stator, Hs0=Hs0_Stator, Hs1=Hs1_Stator, Hs2=Hs2_Stator, Bs0=Bs0_Stator, Bs1=Bs1_Stator, Bs2=Bs2_Stator, Rs=Rs_Stator, FilletType=1, Layers=Layers, CoilPitch=-6, EndExt=WdgExt_Avg, SpanExt/SpanGap=SpanExt_F, SegAngle=SegAngle_Coil_Armature, 1stPitch=0, 2ndPitch=6, 2ndSpanExt/SpanGap=SpanExt_R, WireWidth=WireWidth, WireThick=WireThick, WireRad=WireRad, LayerSetGap=LayerGap, LayerSetIdx=2, LayerGap=LayerGap, WindingType=1, CoilSetIdx=0, LenRegion=Model_Length, InfoCoil=4)
  Ph3_P2_C11_1.rotate(axis=Z, angle=60deg)
  Ph3_P2_C15_1 = user_primitive(RMxprt/HairpinCoil.dll, DiaGap=DiaGap_Hairpin, DiaYoke=DiaStatorYoke, Length=Stator_Lam_Length, Skew=StatorSkewAngle, Slots=SlotNumber_Stator, SlotType=SlotType_Stator, Hs0=Hs0_Stator, Hs1=Hs1_Stator, Hs2=Hs2_Stator, Bs0=Bs0_Stator, Bs1=Bs1_Stator, Bs2=Bs2_Stator, Rs=Rs_Stator, FilletType=1, Layers=Layers, CoilPitch=-6, EndExt=WdgExt_Avg, SpanExt/SpanGap=SpanExt_F, SegAngle=SegAngle_Coil_Armature, 1stPitch=0, 2ndPitch=6, 2ndSpanExt/SpanGap=SpanExt_R, WireWidth=WireWidth, WireThick=WireThick, WireRad=WireRad, LayerSetGap=LayerGap, LayerSetIdx=0, LayerGap=LayerGap, WindingType=1, CoilSetIdx=0, LenRegion=Model_Length, InfoCoil=4)
  Ph3_P2_C15_1.rotate(axis=Z, angle=67.5deg)
  Ph3_P2_C19_1 = user_primitive(RMxprt/HairpinCoil.dll, DiaGap=DiaGap_Hairpin, DiaYoke=DiaStatorYoke, Length=Stator_Lam_Length, Skew=StatorSkewAngle, Slots=SlotNumber_Stator, SlotType=SlotType_Stator, Hs0=Hs0_Stator, Hs1=Hs1_Stator, Hs2=Hs2_Stator, Bs0=Bs0_Stator, Bs1=Bs1_Stator, Bs2=Bs2_Stator, Rs=Rs_Stator, FilletType=1, Layers=Layers, CoilPitch=-6, EndExt=WdgExt_Avg, SpanExt/SpanGap=SpanExt_F, SegAngle=SegAngle_Coil_Armature, 1stPitch=0, 2ndPitch=6, 2ndSpanExt/SpanGap=SpanExt_R, WireWidth=WireWidth, WireThick=WireThick, WireRad=WireRad, LayerSetGap=LayerGap, LayerSetIdx=1, LayerGap=LayerGap, WindingType=1, CoilSetIdx=0, LenRegion=Model_Length, InfoCoil=4)
  Ph3_P2_C19_1.rotate(axis=Z, angle=60deg)
  Ph3_P2_C23_1 = user_primitive(RMxprt/HairpinCoil.dll, DiaGap=DiaGap_Hairpin, DiaYoke=DiaStatorYoke, Length=Stator_Lam_Length, Skew=StatorSkewAngle, Slots=SlotNumber_Stator, SlotType=SlotType_Stator, Hs0=Hs0_Stator, Hs1=Hs1_Stator, Hs2=Hs2_Stator, Bs0=Bs0_Stator, Bs1=Bs1_Stator, Bs2=Bs2_Stator, Rs=Rs_Stator, FilletType=1, Layers=Layers, CoilPitch=-6, EndExt=WdgExt_Avg, SpanExt/SpanGap=SpanExt_F, SegAngle=SegAngle_Coil_Armature, 1stPitch=0, 2ndPitch=6, 2ndSpanExt/SpanGap=SpanExt_R, WireWidth=WireWidth, WireThick=WireThick, WireRad=WireRad, LayerSetGap=LayerGap, LayerSetIdx=2, LayerGap=LayerGap, WindingType=1, CoilSetIdx=0, LenRegion=Model_Length, InfoCoil=4)
  Ph3_P2_C23_1.rotate(axis=Z, angle=67.5deg)
  Ph1_P1_C1_2 [Copper (Pure)_20C [ref. Temp]] = Ph1_P1_C1_1.separate_bodies()
  Ph1_P1_C1_1.delete()
  Ph1_P1_C5_2 [Copper (Pure)_20C [ref. Temp]] = Ph1_P1_C5_1.separate_bodies()
  Ph1_P1_C5_1.delete()
  Ph1_P1_C9_2 [Copper (Pure)_20C [ref. Temp]] = Ph1_P1_C9_1.separate_bodies()
  Ph1_P1_C9_1.delete()
  Ph1_P1_C13_2 [Copper (Pure)_20C [ref. Temp]] = Ph1_P1_C13_1.separate_bodies()
  Ph1_P1_C13_1.delete()
  Ph1_P1_C17_2 [Copper (Pure)_20C [ref. Temp]] = Ph1_P1_C17_1.separate_bodies()
  Ph1_P1_C17_1.delete()
  Ph1_P1_C21_2 [Copper (Pure)_20C [ref. Temp]] = Ph1_P1_C21_1.separate_bodies()
  Ph1_P1_C21_1.delete()
  Ph1_P2_C1_1.separate_bodies()
  Ph1_P2_C5_1.separate_bodies()
  Ph1_P2_C9_1.separate_bodies()
  Ph1_P2_C13_1.separate_bodies()
  Ph1_P2_C17_1.separate_bodies()
  Ph1_P2_C21_1.separate_bodies()
  Ph2_P1_C4_2 [Copper (Pure)_20C [ref. Temp]] = Ph2_P1_C4_1.separate_bodies()
  Ph2_P1_C4_1.delete()
  Ph2_P1_C8_2 [Copper (Pure)_20C [ref. Temp]] = Ph2_P1_C8_1.separate_bodies()
  Ph2_P1_C8_1.delete()
  Ph2_P1_C12_2 [Copper (Pure)_20C [ref. Temp]] = Ph2_P1_C12_1.separate_bodies()
  Ph2_P1_C12_1.delete()
  Ph2_P1_C16_2 [Copper (Pure)_20C [ref. Temp]] = Ph2_P1_C16_1.separate_bodies()
  Ph2_P1_C16_1.delete()
  Ph2_P1_C20_2 [Copper (Pure)_20C [ref. Temp]] = Ph2_P1_C20_1.separate_bodies()
  Ph2_P1_C20_1.delete()
  Ph2_P1_C24_2 [Copper (Pure)_20C [ref. Temp]] = Ph2_P1_C24_1.separate_bodies()
  Ph2_P1_C24_1.delete()
  Ph2_P2_C2_1.separate_bodies()
  Ph2_P2_C6_1.separate_bodies()
  Ph2_P2_C10_1.separate_bodies()
  Ph2_P2_C14_1.separate_bodies()
  Ph2_P2_C18_1.separate_bodies()
  Ph2_P2_C22_1.separate_bodies()
  Ph3_P1_C2_1.separate_bodies()
  Ph3_P1_C6_1.separate_bodies()
  Ph3_P1_C10_1.separate_bodies()
  Ph3_P1_C14_1.separate_bodies()
  Ph3_P1_C18_1.separate_bodies()
  Ph3_P1_C22_1.separate_bodies()
  Ph3_P2_C3_2 [Copper (Pure)_20C [ref. Temp]] = Ph3_P2_C3_1.separate_bodies()
  Ph3_P2_C3_1.delete()
  Ph3_P2_C7_2 [Copper (Pure)_20C [ref. Temp]] = Ph3_P2_C7_1.separate_bodies()
  Ph3_P2_C7_1.delete()
  Ph3_P2_C11_2 [Copper (Pure)_20C [ref. Temp]] = Ph3_P2_C11_1.separate_bodies()
  Ph3_P2_C11_1.delete()
  Ph3_P2_C15_2 [Copper (Pure)_20C [ref. Temp]] = Ph3_P2_C15_1.separate_bodies()
  Ph3_P2_C15_1.delete()
  Ph3_P2_C19_2 [Copper (Pure)_20C [ref. Temp]] = Ph3_P2_C19_1.separate_bodies()
  Ph3_P2_C19_1.delete()
  Ph3_P2_C23_2 [Copper (Pure)_20C [ref. Temp]] = Ph3_P2_C23_1.separate_bodies()
  Ph3_P2_C23_1.delete()
  coordinate_system CS_L1_1Magnet2S3_1 = origin=(-58.472644mm, 12.359773mm, 0mm) x=(0.67097875mm, -1.0137383mm, 0mm) y=(1.0137383mm, 0.67097875mm, 0mm)
  coordinate_system CS_L1_1Magnet2N3_1 = origin=(-50.086083mm, -32.606724mm, 0mm) x=(-1.1912749mm, 0.24236761mm, 0mm) y=(-0.24236761mm, -1.1912749mm, 0mm)
  coordinate_system CS_L1_1Magnet2N2_1 = origin=(-32.606724mm, 50.086083mm, 0mm) x=(0.24236761mm, 1.1912749mm, 0mm) y=(-1.1912749mm, 0.24236761mm, 0mm)
  coordinate_system CS_L1_1Magnet2S4_1 = origin=(-12.359773mm, -58.472644mm, 0mm) x=(1.0137383mm, 0.67097875mm, 0mm) y=(-0.67097875mm, 1.0137383mm, 0mm)
  coordinate_system CS_L1_1Magnet2S2_1 = origin=(12.359773mm, 58.472644mm, 0mm) x=(-1.0137383mm, -0.67097875mm, 0mm) y=(0.67097875mm, -1.0137383mm, 0mm)
  coordinate_system CS_L1_1Magnet2N4_1 = origin=(32.606724mm, -50.086083mm, 0mm) x=(-0.24236761mm, -1.1912749mm, 0mm) y=(1.1912749mm, -0.24236761mm, 0mm)
  coordinate_system CS_L1_1Magnet2S1_1 = origin=(58.472644mm, -12.359773mm, 0mm) x=(-0.67097875mm, 1.0137383mm, 0mm) y=(-1.0137383mm, -0.67097875mm, 0mm)
  coordinate_system CS_L1_1Magnet1N3_1 = origin=(-58.472644mm, -12.359773mm, 0mm) x=(-0.67097875mm, -1.0137383mm, 0mm) y=(1.0137383mm, -0.67097875mm, 0mm)
  coordinate_system CS_L1_1Magnet1S3_1 = origin=(-50.086083mm, 32.606724mm, 0mm) x=(1.1912749mm, 0.24236761mm, 0mm) y=(-0.24236761mm, 1.1912749mm, 0mm)
  coordinate_system CS_L1_1Magnet1S4_1 = origin=(-32.606724mm, -50.086083mm, 0mm) x=(-0.24236761mm, 1.1912749mm, 0mm) y=(-1.1912749mm, -0.24236761mm, 0mm)
  coordinate_system CS_L1_1Magnet1N2_1 = origin=(-12.359773mm, 58.472644mm, 0mm) x=(-1.0137383mm, 0.67097875mm, 0mm) y=(-0.67097875mm, -1.0137383mm, 0mm)
  coordinate_system CS_L1_1Magnet1N4_1 = origin=(12.359773mm, -58.472644mm, 0mm) x=(1.0137383mm, -0.67097875mm, 0mm) y=(0.67097875mm, 1.0137383mm, 0mm)
  coordinate_system CS_L1_1Magnet1S2_1 = origin=(32.606724mm, 50.086083mm, 0mm) x=(0.24236761mm, -1.1912749mm, 0mm) y=(1.1912749mm, 0.24236761mm, 0mm)
  coordinate_system CS_L1_1Magnet1S1_1 = origin=(50.086083mm, -32.606724mm, 0mm) x=(-1.1912749mm, -0.24236761mm, 0mm) y=(0.24236761mm, -1.1912749mm, 0mm)
  coordinate_system CS_L2_1Magnet2S3_1 = origin=(-64.026812mm, 19.530109mm, 0mm) x=(1.07734mm, -0.56321972mm, 0mm) y=(0.56321972mm, 1.07734mm, 0mm)
  coordinate_system CS_L2_1Magnet2N3_1 = origin=(-59.083666mm, -31.463921mm, 0mm) x=(-1.1600509mm, -0.36353791mm, 0mm) y=(0.36353791mm, -1.1600509mm, 0mm)
  coordinate_system CS_L2_1Magnet2N2_1 = origin=(-31.463921mm, 59.083666mm, 0mm) x=(-0.36353791mm, 1.1600509mm, 0mm) y=(-1.1600509mm, -0.36353791mm, 0mm)
  coordinate_system CS_L2_1Magnet2S4_1 = origin=(-19.530109mm, -64.026812mm, 0mm) x=(0.56321972mm, 1.07734mm, 0mm) y=(-1.07734mm, 0.56321972mm, 0mm)
  coordinate_system CS_L2_1Magnet2S2_1 = origin=(19.530109mm, 64.026812mm, 0mm) x=(-0.56321972mm, -1.07734mm, 0mm) y=(1.07734mm, -0.56321972mm, 0mm)
  coordinate_system CS_L2_1Magnet2N4_1 = origin=(31.463921mm, -59.083666mm, 0mm) x=(0.36353791mm, -1.1600509mm, 0mm) y=(1.1600509mm, 0.36353791mm, 0mm)
  coordinate_system CS_L2_1Magnet2S1_1 = origin=(64.026812mm, -19.530109mm, 0mm) x=(-1.07734mm, 0.56321972mm, 0mm) y=(-0.56321972mm, -1.07734mm, 0mm)
  coordinate_system CS_L2_1Magnet1N3_1 = origin=(-64.026812mm, -19.530109mm, 0mm) x=(-1.07734mm, -0.56321972mm, 0mm) y=(0.56321972mm, -1.07734mm, 0mm)
  coordinate_system CS_L2_1Magnet1S3_1 = origin=(-59.083666mm, 31.463921mm, 0mm) x=(1.1600509mm, -0.36353791mm, 0mm) y=(0.36353791mm, 1.1600509mm, 0mm)
  coordinate_system CS_L2_1Magnet1S4_1 = origin=(-31.463921mm, -59.083666mm, 0mm) x=(0.36353791mm, 1.1600509mm, 0mm) y=(-1.1600509mm, 0.36353791mm, 0mm)
  coordinate_system CS_L2_1Magnet1N2_1 = origin=(-19.530109mm, 64.026812mm, 0mm) x=(-0.56321972mm, 1.07734mm, 0mm) y=(-1.07734mm, -0.56321972mm, 0mm)
  coordinate_system CS_L2_1Magnet1N4_1 = origin=(19.530109mm, -64.026812mm, 0mm) x=(0.56321972mm, -1.07734mm, 0mm) y=(1.07734mm, 0.56321972mm, 0mm)
  coordinate_system CS_L2_1Magnet1S2_1 = origin=(31.463921mm, 59.083666mm, 0mm) x=(-0.36353791mm, -1.1600509mm, 0mm) y=(1.1600509mm, -0.36353791mm, 0mm)
  coordinate_system CS_L2_1Magnet1S1_1 = origin=(59.083666mm, -31.463921mm, 0mm) x=(-1.1600509mm, 0.36353791mm, 0mm) y=(-0.36353791mm, -1.1600509mm, 0mm)
  Band_Tool = user_primitive(RMxprt/Band.dll, DiaGap=1mm, DiaYoke=DiaOuter, Length=0mm, SegAngle=SegAngle, Fractions=SymmetryFactor, HalfAxial=HalfAxial, InfoCore=1)
  Whole_Region [vacuum] = user_primitive(RMxprt/Band.dll, DiaGap=DiaGap+Airgap, DiaYoke=DiaOuter, Length=0mm, SegAngle=SegAngle, Fractions=SymmetryFactor, HalfAxial=HalfAxial, InfoCore=100)
  Band_Tool_1 = Band_Tool.copy()
  Stator_2.subtract(Band_Tool_1)
  Band_Tool_2 = Band_Tool.copy()
  Rotor_1.subtract(Band_Tool_2)
  Band_Tool_21 = Band_Tool.copy()
  Rotor_Pocket_9.subtract(Band_Tool_21)
  Band_Tool_22 = Band_Tool.copy()
  L1_1Magnet2N1_1.subtract(Band_Tool_22)
  Band_Tool_37 = Band_Tool.copy()
  Rotor_Pocket_17.subtract(Band_Tool_37)
  Band_Tool_38 = Band_Tool.copy()
  L1_1Magnet1N1_1.subtract(Band_Tool_38)
  Band_Tool_49 = Band_Tool.copy()
  Rotor_Pocket_23.subtract(Band_Tool_49)
  Band_Tool_50 = Band_Tool.copy()
  L2_1Magnet2N1_1.subtract(Band_Tool_50)
  Band_Tool_65 = Band_Tool.copy()
  Rotor_Pocket_31.subtract(Band_Tool_65)
  Band_Tool_66 = Band_Tool.copy()
  L2_1Magnet1N1_1.subtract(Band_Tool_66)
  Band_Tool_67 = Band_Tool.copy()
  Shaft.subtract(Band_Tool_67)
  Band_Tool_74 = Band_Tool.copy()
  Ph1_P2_C1_1.subtract(Band_Tool_74)
  Band_Tool_75 = Band_Tool.copy()
  Ph1_P2_C5_1.subtract(Band_Tool_75)
  Band_Tool_76 = Band_Tool.copy()
  Ph1_P2_C9_1.subtract(Band_Tool_76)
  Band_Tool_77 = Band_Tool.copy()
  Ph1_P2_C13_1.subtract(Band_Tool_77)
  Band_Tool_78 = Band_Tool.copy()
  Ph1_P2_C17_1.subtract(Band_Tool_78)
  Band_Tool_79 = Band_Tool.copy()
  Ph1_P2_C21_1.subtract(Band_Tool_79)
  Band_Tool_86 = Band_Tool.copy()
  Ph2_P2_C2_1.subtract(Band_Tool_86)
  Band_Tool_87 = Band_Tool.copy()
  Ph2_P2_C6_1.subtract(Band_Tool_87)
  Band_Tool_88 = Band_Tool.copy()
  Ph2_P2_C10_1.subtract(Band_Tool_88)
  Band_Tool_89 = Band_Tool.copy()
  Ph2_P2_C14_1.subtract(Band_Tool_89)
  Band_Tool_90 = Band_Tool.copy()
  Ph2_P2_C18_1.subtract(Band_Tool_90)
  Band_Tool_91 = Band_Tool.copy()
  Ph2_P2_C22_1.subtract(Band_Tool_91)
  Band_Tool_92 = Band_Tool.copy()
  Ph3_P1_C2_1.subtract(Band_Tool_92)
  Band_Tool_93 = Band_Tool.copy()
  Ph3_P1_C6_1.subtract(Band_Tool_93)
  Band_Tool_94 = Band_Tool.copy()
  Ph3_P1_C10_1.subtract(Band_Tool_94)
  Band_Tool_95 = Band_Tool.copy()
  Ph3_P1_C14_1.subtract(Band_Tool_95)
  Band_Tool_96 = Band_Tool.copy()
  Ph3_P1_C18_1.subtract(Band_Tool_96)
  Band_Tool_97 = Band_Tool.copy()
  Ph3_P1_C22_1.subtract(Band_Tool_97)
  Band_Tool_104 = Band_Tool.copy()
  Ph1_P1_C1_2.subtract(Band_Tool_104)
  Band_Tool_105 = Band_Tool.copy()
  Ph1_P1_C5_2.subtract(Band_Tool_105)
  Band_Tool_106 = Band_Tool.copy()
  Ph1_P1_C9_2.subtract(Band_Tool_106)
  Band_Tool_107 = Band_Tool.copy()
  Ph1_P1_C13_2.subtract(Band_Tool_107)
  Band_Tool_108 = Band_Tool.copy()
  Ph1_P1_C17_2.subtract(Band_Tool_108)
  Band_Tool_109 = Band_Tool.copy()
  Ph1_P1_C21_2.subtract(Band_Tool_109)
  Band_Tool_116 = Band_Tool.copy()
  Ph2_P1_C4_2.subtract(Band_Tool_116)
  Band_Tool_117 = Band_Tool.copy()
  Ph2_P1_C8_2.subtract(Band_Tool_117)
  Band_Tool_118 = Band_Tool.copy()
  Ph2_P1_C12_2.subtract(Band_Tool_118)
  Band_Tool_119 = Band_Tool.copy()
  Ph2_P1_C16_2.subtract(Band_Tool_119)
  Band_Tool_120 = Band_Tool.copy()
  Ph2_P1_C20_2.subtract(Band_Tool_120)
  Band_Tool_121 = Band_Tool.copy()
  Ph2_P1_C24_2.subtract(Band_Tool_121)
  Band_Tool_134 = Band_Tool.copy()
  Ph3_P2_C3_2.subtract(Band_Tool_134)
  Band_Tool_135 = Band_Tool.copy()
  Ph3_P2_C7_2.subtract(Band_Tool_135)
  Band_Tool_136 = Band_Tool.copy()
  Ph3_P2_C11_2.subtract(Band_Tool_136)
  Band_Tool_137 = Band_Tool.copy()
  Ph3_P2_C15_2.subtract(Band_Tool_137)
  Band_Tool_138 = Band_Tool.copy()
  Ph3_P2_C19_2.subtract(Band_Tool_138)
  Band_Tool_139 = Band_Tool.copy()
  Band_Tool.delete()
  Ph3_P2_C23_2.subtract(Band_Tool_139)
  Independent = polyline((0mm, 0mm, 0mm) (99mm, 0mm, 0mm))
  Dependent = polyline((0mm, 0mm, 0mm) (70.003571mm, 70.003571mm, 0mm))
  RotatingBand [vacuum] = circle(normal=Z, centre=(0mm, 0mm, 0mm), radius=DiaGap/2 - Airgap/2, segments=1440)
  Whole_Region1 = user_primitive(RMxprt/Band.dll, DiaGap=DiaGap+Airgap, DiaYoke=DiaOuter, Length=0mm, SegAngle=SegAngle, Fractions=SymmetryFactor, HalfAxial=HalfAxial, InfoCore=100)
  RotatingBand.intersect(Whole_Region1)
  InnerBand [vacuum] = circle(normal=Z, centre=(0mm, 0mm, 0mm), radius=DiaGap/2 - 3*Airgap/4, segments=1440)
  Whole_Region2 = user_primitive(RMxprt/Band.dll, DiaGap=DiaGap+Airgap, DiaYoke=DiaOuter, Length=0mm, SegAngle=SegAngle, Fractions=SymmetryFactor, HalfAxial=HalfAxial, InfoCore=100)
  InnerBand.intersect(Whole_Region2)
  OuterBand [vacuum] = circle(normal=Z, centre=(0mm, 0mm, 0mm), radius=DiaGap/2 - Airgap/4, segments=1440)
  Whole_Region3 = user_primitive(RMxprt/Band.dll, DiaGap=DiaGap+Airgap, DiaYoke=DiaOuter, Length=0mm, SegAngle=SegAngle, Fractions=SymmetryFactor, HalfAxial=HalfAxial, InfoCore=100)
  OuterBand.intersect(Whole_Region3)
  Circle1 = circle(normal=Z, centre=(0mm, 0mm, 0mm), radius=DiaGap/2 + (DiaOuter - DiaGap)/2*(1/7.5))
  Whole_Region4 = user_primitive(RMxprt/Band.dll, DiaGap=DiaGap+Airgap, DiaYoke=DiaOuter, Length=0mm, SegAngle=SegAngle, Fractions=SymmetryFactor, HalfAxial=HalfAxial, InfoCore=100)
  Circle1.intersect(Whole_Region4)
  Stator_1 [NO18-1160_180C_SF0.97] = user_primitive(RMxprt/VentSlotCore.dll, DiaGap=DiaGap, DiaYoke=DiaStatorYoke, Length=Stator_Lam_Length, Skew=StatorSkewAngle, Slots=SlotNumber_Stator, SlotType=SlotType_Stator, Hs0=Hs0_Stator, Hs01=0mm, Hs1=Hs1_Stator, Hs2=12.551463mm, Bs0=Bs0_Stator, Bs1=4.63mm, Bs2=4.63mm, Rs=Rs_Stator, FilletType=FilletType_Stator, HalfSlot=0, VentHoles=0, HoleDiaIn=0mm, HoleDiaOut=0mm, HoleLocIn=0mm, HoleLocOut=0mm, VentDucts=0, DuctWidth=0mm, DuctPitch=0mm, SegAngle=SegAngle, LenRegion=0mm, InfoCore=0)
  Band_Tool1 = user_primitive(RMxprt/Band.dll, DiaGap=1mm, DiaYoke=DiaOuter, Length=0mm, SegAngle=SegAngle, Fractions=SymmetryFactor, HalfAxial=HalfAxial, InfoCore=1)
  Band_Tool_140 = Band_Tool1.copy()
  Stator_1.subtract(Band_Tool_140)
  Band_Tool1.delete()
  Stator_1.intersect(Circle1)
  Stator_Lamination_Primitive1_1 = Stator_1.copy()
  Stator_2.subtract(Stator_Lamination_Primitive1_1)
  Circle2 = circle(normal=Z, centre=(0mm, 0mm, 0mm), radius=66.70832mm)
  Whole_Region5 = user_primitive(RMxprt/Band.dll, DiaGap=DiaGap+Airgap, DiaYoke=DiaOuter, Length=0mm, SegAngle=SegAngle, Fractions=SymmetryFactor, HalfAxial=HalfAxial, InfoCore=100)
  Circle2.intersect(Whole_Region5)
  Rotor_2 [NO18-1160_140C_SF0.97] = circle(normal=Z, centre=(0mm, 0mm, 0mm), radius=70.27mm)
  Rotor_Subtract_11 = circle(normal=Z, centre=(0mm, 0mm, 0mm), radius=23.455mm)
  Rotor_2.subtract(Rotor_Subtract_11)
  Band_Tool2 = user_primitive(RMxprt/Band.dll, DiaGap=1mm, DiaYoke=DiaOuter, Length=0mm, SegAngle=SegAngle, Fractions=SymmetryFactor, HalfAxial=HalfAxial, InfoCore=1)
  Band_Tool_141 = Band_Tool2.copy()
  Rotor_2.subtract(Band_Tool_141)
  Band_Tool2.delete()
  Rotor_2.intersect(Circle2)
  Rotor_2_1 = Rotor_2.copy()
  Rotor_1.subtract(Rotor_2_1)
  Rotor_Pocket_17_1 = Rotor_Pocket_17.copy()
  Rotor_Pocket_23_1 = Rotor_Pocket_23.copy()
  Rotor_Pocket_31_1 = Rotor_Pocket_31.copy()
  Rotor_Pocket_9_1 = Rotor_Pocket_9.copy()
  Rotor_1.subtract(Rotor_Pocket_17_1, Rotor_Pocket_23_1, Rotor_Pocket_31_1, Rotor_Pocket_9_1)
  Rotor_Pocket_17_2 = Rotor_Pocket_17.copy()
  Rotor_Pocket_23_2 = Rotor_Pocket_23.copy()
  Rotor_Pocket_31_2 = Rotor_Pocket_31.copy()
  Rotor_Pocket_9_2 = Rotor_Pocket_9.copy()
  Rotor_2.subtract(Rotor_Pocket_17_2, Rotor_Pocket_23_2, Rotor_Pocket_31_2, Rotor_Pocket_9_2)
  Circle3 = circle(normal=Z, centre=(0mm, 0mm, 0mm), radius=46.097722mm)
  Whole_Region6 = user_primitive(RMxprt/Band.dll, DiaGap=DiaGap+Airgap, DiaYoke=DiaOuter, Length=0mm, SegAngle=SegAngle, Fractions=SymmetryFactor, HalfAxial=HalfAxial, InfoCore=100)
  Circle3.intersect(Whole_Region6)
  Rotor_3 [NO18-1160_140C_SF0.97] = circle(normal=Z, centre=(0mm, 0mm, 0mm), radius=70.27mm)
  Rotor_Subtract_12 = circle(normal=Z, centre=(0mm, 0mm, 0mm), radius=23.455mm)
  Rotor_3.subtract(Rotor_Subtract_12)
  Band_Tool4 = user_primitive(RMxprt/Band.dll, DiaGap=1mm, DiaYoke=DiaOuter, Length=0mm, SegAngle=SegAngle, Fractions=SymmetryFactor, HalfAxial=HalfAxial, InfoCore=1)
  Band_Tool_146 = Band_Tool4.copy()
  Rotor_3.subtract(Band_Tool_146)
  Band_Tool4.delete()
  Circle4 = circle(normal=Z, centre=(0mm, 0mm, 0mm), radius=66.70832mm)
  Whole_Region7 = user_primitive(RMxprt/Band.dll, DiaGap=DiaGap+Airgap, DiaYoke=DiaOuter, Length=0mm, SegAngle=SegAngle, Fractions=SymmetryFactor, HalfAxial=HalfAxial, InfoCore=100)
  Circle4.intersect(Whole_Region7)
  Rotor_3.intersect(Circle4)
  Rotor_Pocket_33 = polyline(z=0mm, xy in mm: (48.7926, 15.8167) (65.0201, 5.076) (65.2645, 4.9142) (65.4432, 4.8128) (65.6339, 4.7368) (66.8645, 4.3417) (67.0909, 4.288) (67.323, 4.27) (68.5542, 4.27) (68.9198, 4.4289) (69.053, 4.8047) (68.9315, 6.3125) (68.7771, 7.8174) (68.6351, 8.2302) (68.3318, 8.5442) (67.6252, 9.0119) (51.8147, 19.4767) (51.6505, 19.5854) (50.9663, 19.8277) (50.2485, 19.7204) (48.3318, 18.9264) (47.4127, 17.6844) (48.0779, 16.2898) (48.7926, 15.8167), closed, covered, Arc from point 2 over 3, Arc from point 5 over 3, Arc from point 8 over 3, Arc from point 10 over 3, Arc from point 12 over 3, Arc from point 17 over 3, Arc from point 20 over 3)
  Band_Tool3 = user_primitive(RMxprt/Band.dll, DiaGap=1mm, DiaYoke=DiaOuter, Length=0mm, SegAngle=SegAngle, Fractions=SymmetryFactor, HalfAxial=HalfAxial, InfoCore=1)
  Band_Tool_142 = Band_Tool3.copy()
  Band_Tool_143 = Band_Tool3.copy()
  Rotor_Pocket_33.subtract(Band_Tool_143)
  Rotor_Pocket_17_3 = Rotor_Pocket_33.copy()
  Rotor_Pocket_34 = polyline(z=0mm, xy in mm: (55.8125, 36.4691) (55.8337, 36.2755) (55.8797, 36.0864) (55.9706, 35.7962) (59.0002, 26.1289) (59.625, 25.4146) (60.5737, 25.3935) (61.4274, 25.7471) (62.0006, 26.2953) (62.0535, 27.0867) (59.0242, 36.7531) (58.7793, 37.5344) (58.7399, 37.6359) (58.6873, 37.7312) (57.9666, 38.8293) (57.2254, 39.9136) (56.9069, 40.098) (56.561, 39.9723) (56.1634, 39.5747) (55.826, 39.0575) (55.7255, 38.4482) (55.8125, 36.4691), closed, covered, Arc from point 0 over 3, Arc from point 4 over 3, Arc from point 7 over 3, Arc from point 11 over 3, Arc from point 13 over 3, Arc from point 15 over 3, Arc from point 18 over 3)
  Band_Tool_144 = Band_Tool3.copy()
  Rotor_Pocket_34.subtract(Band_Tool_144)
  Rotor_Pocket_23_3 = Rotor_Pocket_34.copy()
  Rotor_Pocket_35 = polyline(z=0mm, xy in mm: (64.889, 14.2654) (65.0298, 13.996) (65.131, 13.8296) (65.2529, 13.6778) (66.5909, 12.2169) (67.0928, 11.8571) (67.6971, 11.7299) (68.2594, 11.73) (68.5929, 11.8856) (68.6877, 12.2413) (68.4451, 13.5321) (68.1782, 14.8182) (68.148, 14.9227) (68.1041, 15.0224) (67.7248, 15.748) (63.0316, 24.7252) (62.4346, 25.2474) (61.6417, 25.2297) (60.788, 24.8761) (60.1321, 24.1903) (60.1954, 23.2434) (64.889, 14.2654), closed, covered, Arc from point 1 over 3, Arc from point 4 over 3, Arc from point 7 over 3, Arc from point 9 over 3, Arc from point 11 over 3, Arc from point 15 over 3, Arc from point 18 over 3)
  Band_Tool_145 = Band_Tool3.copy()
  Rotor_Pocket_35.subtract(Band_Tool_145)
  Rotor_Pocket_31_3 = Rotor_Pocket_35.copy()
  Rotor_Pocket_32 = polyline(z=0mm, xy in mm: (45.5148, 22.4775) (46.0306, 21.021) (47.5588, 20.7927) (49.4755, 21.5866) (50.0589, 22.0183) (50.3714, 22.6734) (50.4107, 22.8664) (54.1907, 41.4458) (54.3596, 42.2762) (54.352, 42.7126) (54.1605, 43.1049) (53.2056, 44.2782) (52.2253, 45.4304) (51.8654, 45.6019) (51.4945, 45.4558) (50.6239, 44.5852) (50.4726, 44.4083) (50.3504, 44.2102) (49.7597, 43.0607) (49.6785, 42.8721) (49.6239, 42.6741) (49.5654, 42.3868) (45.6857, 23.3175) (45.5148, 22.4775), closed, covered, Arc from point 0 over 3, Arc from point 3 over 3, Arc from point 8 over 3, Arc from point 10 over 3, Arc from point 12 over 3, Arc from point 15 over 3, Arc from point 18 over 3)
  Rotor_Pocket_32.subtract(Band_Tool_142)
  Rotor_Pocket_9_3 = Rotor_Pocket_32.copy()
  Rotor_3.subtract(Rotor_Pocket_17_3, Rotor_Pocket_23_3, Rotor_Pocket_31_3, Rotor_Pocket_9_3)
  [Rotor_Pocket_32..Rotor_Pocket_35, Band_Tool3].delete()
  Rotor_3.intersect(Circle3)
  Rotor_3_1 = Rotor_3.copy()
  Rotor_2.subtract(Rotor_3_1)
motion:
  MotionSetup1: Band Move_Type=Rotate Coordinate_System=Global Axis=Z Is_Positive=true InitPos=InitialPositionMD Angular_Velocity=MachineRPM Objects=RotatingBand
  Moving1: Moving Objects=[Rotor_1, Rotor_Pocket_9, L1_1Magnet2N1_1, Rotor_Pocket_17, L1_1Magnet1N1_1, Rotor_Pocket_23, L2_1Magnet2N1_1, Rotor_Pocket_31, L2_1Magnet1N1_1, Shaft, InnerBand, Rotor_2, Rotor_3]
boundaries and excitations:
  Independent1: Independent Edges=Independent.edge(at (49.5, 0, 0))
  Dependent1: Dependent Edges=Dependent.edge(at (35.0018, 35.0018, 0)) Independent=Independent1 RelationIsSame=false
  VectorPotential1: Vector Potential Edges=Whole_Region.edge(at (91.4641, 37.8857, 0)) Value=0
  CT_Ph1_P1_C1_Go: Coil Objects=Ph1_P1_C1_2 Conductor_number=1 Winding=WG_Ph1_P1 PolarityType=Positive
  CT_Ph1_P1_C5_Go: Coil Objects=Ph1_P1_C5_2 Conductor_number=1 Winding=WG_Ph1_P1 PolarityType=Positive
  CT_Ph1_P1_C9_Go: Coil Objects=Ph1_P1_C9_2 Conductor_number=1 Winding=WG_Ph1_P1 PolarityType=Positive
  CT_Ph1_P1_C13_Go: Coil Objects=Ph1_P1_C13_2 Conductor_number=1 Winding=WG_Ph1_P1 PolarityType=Positive
  CT_Ph1_P1_C17_Go: Coil Objects=Ph1_P1_C17_2 Conductor_number=1 Winding=WG_Ph1_P1 PolarityType=Positive
  CT_Ph1_P1_C21_Go: Coil Objects=Ph1_P1_C21_2 Conductor_number=1 Winding=WG_Ph1_P1 PolarityType=Positive
  CT_Ph1_P2_C1_Go: Coil Objects=Ph1_P2_C1_1 Conductor_number=1 Winding=WG_Ph1_P1 PolarityType=Positive
  CT_Ph1_P2_C5_Go: Coil Objects=Ph1_P2_C5_1 Conductor_number=1 Winding=WG_Ph1_P1 PolarityType=Positive
  CT_Ph1_P2_C9_Go: Coil Objects=Ph1_P2_C9_1 Conductor_number=1 Winding=WG_Ph1_P1 PolarityType=Positive
  CT_Ph1_P2_C13_Go: Coil Objects=Ph1_P2_C13_1 Conductor_number=1 Winding=WG_Ph1_P1 PolarityType=Positive
  CT_Ph1_P2_C17_Go: Coil Objects=Ph1_P2_C17_1 Conductor_number=1 Winding=WG_Ph1_P1 PolarityType=Positive
  CT_Ph1_P2_C21_Go: Coil Objects=Ph1_P2_C21_1 Conductor_number=1 Winding=WG_Ph1_P1 PolarityType=Positive
  CT_Ph2_P1_C4_Go: Coil Objects=Ph2_P1_C4_2 Conductor_number=1 Winding=WG_Ph2_P1 PolarityType=Positive
  CT_Ph2_P1_C8_Go: Coil Objects=Ph2_P1_C8_2 Conductor_number=1 Winding=WG_Ph2_P1 PolarityType=Positive
  CT_Ph2_P1_C12_Go: Coil Objects=Ph2_P1_C12_2 Conductor_number=1 Winding=WG_Ph2_P1 PolarityType=Positive
  CT_Ph2_P1_C16_Go: Coil Objects=Ph2_P1_C16_2 Conductor_number=1 Winding=WG_Ph2_P1 PolarityType=Positive
  CT_Ph2_P1_C20_Go: Coil Objects=Ph2_P1_C20_2 Conductor_number=1 Winding=WG_Ph2_P1 PolarityType=Positive
  CT_Ph2_P1_C24_Go: Coil Objects=Ph2_P1_C24_2 Conductor_number=1 Winding=WG_Ph2_P1 PolarityType=Positive
  CT_Ph2_P2_C2_Go: Coil Objects=Ph2_P2_C2_1 Conductor_number=1 Winding=WG_Ph2_P1 PolarityType=Positive
  CT_Ph2_P2_C6_Go: Coil Objects=Ph2_P2_C6_1 Conductor_number=1 Winding=WG_Ph2_P1 PolarityType=Positive
  CT_Ph2_P2_C10_Go: Coil Objects=Ph2_P2_C10_1 Conductor_number=1 Winding=WG_Ph2_P1 PolarityType=Positive
  CT_Ph2_P2_C14_Go: Coil Objects=Ph2_P2_C14_1 Conductor_number=1 Winding=WG_Ph2_P1 PolarityType=Positive
  CT_Ph2_P2_C18_Go: Coil Objects=Ph2_P2_C18_1 Conductor_number=1 Winding=WG_Ph2_P1 PolarityType=Positive
  CT_Ph2_P2_C22_Go: Coil Objects=Ph2_P2_C22_1 Conductor_number=1 Winding=WG_Ph2_P1 PolarityType=Positive
  CT_Ph3_P1_C2_Ret: Coil Objects=Ph3_P1_C2_1 Conductor_number=1 Winding=WG_Ph3_P1 PolarityType=Negative
  CT_Ph3_P1_C6_Ret: Coil Objects=Ph3_P1_C6_1 Conductor_number=1 Winding=WG_Ph3_P1 PolarityType=Negative
  CT_Ph3_P1_C10_Ret: Coil Objects=Ph3_P1_C10_1 Conductor_number=1 Winding=WG_Ph3_P1 PolarityType=Negative
  CT_Ph3_P1_C14_Ret: Coil Objects=Ph3_P1_C14_1 Conductor_number=1 Winding=WG_Ph3_P1 PolarityType=Negative
  CT_Ph3_P1_C18_Ret: Coil Objects=Ph3_P1_C18_1 Conductor_number=1 Winding=WG_Ph3_P1 PolarityType=Negative
  CT_Ph3_P1_C22_Ret: Coil Objects=Ph3_P1_C22_1 Conductor_number=1 Winding=WG_Ph3_P1 PolarityType=Negative
  CT_Ph3_P2_C3_Ret: Coil Objects=Ph3_P2_C3_2 Conductor_number=1 Winding=WG_Ph3_P1 PolarityType=Negative
  CT_Ph3_P2_C7_Ret: Coil Objects=Ph3_P2_C7_2 Conductor_number=1 Winding=WG_Ph3_P1 PolarityType=Negative
  CT_Ph3_P2_C11_Ret: Coil Objects=Ph3_P2_C11_2 Conductor_number=1 Winding=WG_Ph3_P1 PolarityType=Negative
  CT_Ph3_P2_C15_Ret: Coil Objects=Ph3_P2_C15_2 Conductor_number=1 Winding=WG_Ph3_P1 PolarityType=Negative
  CT_Ph3_P2_C19_Ret: Coil Objects=Ph3_P2_C19_2 Conductor_number=1 Winding=WG_Ph3_P1 PolarityType=Negative
  CT_Ph3_P2_C23_Ret: Coil Objects=Ph3_P2_C23_2 Conductor_number=1 Winding=WG_Ph3_P1 PolarityType=Negative
  L1_1Magnet2N1_1: Current Objects=L1_1Magnet2N1_1 Current=0A IsSolid=true IsPositive=true
  L1_1Magnet1N1_1: Current Objects=L1_1Magnet1N1_1 Current=0A IsSolid=true IsPositive=true
  L2_1Magnet2N1_1: Current Objects=L2_1Magnet2N1_1 Current=0A IsSolid=true IsPositive=true
  L2_1Magnet1N1_1: Current Objects=L2_1Magnet1N1_1 Current=0A IsSolid=true IsPositive=true
  WG_Ph1_P1: Winding Group Type="PWM Voltage" IsSolid=true Current="IPeak * sin( ( 2 * pi * StatorFrequency * 0 - 0 / 360 * 2 * pi ) + PhaseAdvance )" Resistance=StatorResistance Inductance=EndWindingInductance Voltage=0 ParallelBranchesNum=ParallelPaths
  WG_Ph2_P1: Winding Group Type="PWM Voltage" IsSolid=true Current="IPeak * sin( ( 2 * pi * StatorFrequency * 0 - 120 / 360 * 2 * pi ) + PhaseAdvance )" Resistance=StatorResistance Inductance=EndWindingInductance Voltage=0 ParallelBranchesNum=ParallelPaths
  WG_Ph3_P1: Winding Group Type="PWM Voltage" IsSolid=true Current="IPeak * sin( ( 2 * pi * StatorFrequency * 0 - 240 / 360 * 2 * pi ) + PhaseAdvance )" Resistance=StatorResistance Inductance=EndWindingInductance Voltage=0 ParallelBranchesNum=ParallelPaths
  eddy effects on: L1_1Magnet2N1_1, L1_1Magnet1N1_1, L2_1Magnet2N1_1, L2_1Magnet1N1_1
  core loss on: Stator_2, Rotor_1, Stator_1, Rotor_2, Rotor_3
  Y connection: WG_Ph1_P1, WG_Ph2_P1, WG_Ph3_P1
mesh:
  CylindricalGap1: CylindricalGap Objects=RotatingBand Objects=RotatingBand
  Rotor_1: LengthBased RefineInside Objects=Rotor_1 MaxLength=1mm
  Rotor_2: LengthBased RefineInside Objects=Rotor_2 MaxLength=2mm
  Stator_1: LengthBased RefineInside Objects=Stator_2 MaxLength=2mm
  Stator_2: LengthBased RefineInside Objects=Stator_1 MaxLength=1mm
  Conductors: LengthBased RefineInside Objects=[Ph1_P1_C1_2, Ph1_P1_C5_2, Ph1_P1_C9_2, Ph1_P1_C13_2, Ph1_P1_C17_2, Ph1_P1_C21_2, Ph1_P2_C1_1, Ph1_P2_C5_1, Ph1_P2_C9_1, Ph1_P2_C13_1, Ph1_P2_C17_1, Ph1_P2_C21_1, Ph2_P1_C4_2, Ph2_P1_C8_2, Ph2_P1_C12_2, Ph2_P1_C16_2, Ph2_P1_C20_2, Ph2_P1_C24_2, Ph2_P2_C2_1, Ph2_P2_C6_1, Ph2_P2_C10_1, Ph2_P2_C14_1, Ph2_P2_C18_1, Ph2_P2_C22_1, Ph3_P1_C2_1, Ph3_P1_C6_1, Ph3_P1_C10_1, Ph3_P1_C14_1, Ph3_P1_C18_1, Ph3_P1_C22_1, Ph3_P2_C3_2, Ph3_P2_C7_2, Ph3_P2_C11_2, Ph3_P2_C15_2, Ph3_P2_C19_2, Ph3_P2_C23_2] MaxLength=0.5mm
  Rotor_3: LengthBased RefineInside Objects=Rotor_3 MaxLength=5mm
temperatures:
  Stator_2, Rotor_1, Rotor_Pocket_9, Rotor_Pocket_17, Rotor_Pocket_23, Rotor_Pocket_31, Shaft, Whole_Region, Independent, Dependent, RotatingBand, InnerBand, Whole_Region2, OuterBand, Whole_Region3, Stator_1, Band_Tool1, Band_Tool_140, Rotor_2, Rotor_Subtract_11, Band_Tool2, Band_Tool_141, Rotor_3, Rotor_Pocket_32..Rotor_Pocket_35, Band_Tool3, Band_Tool_142..Band_Tool_145, Circle4, Whole_Region7, Rotor_Subtract_12, Band_Tool4, Band_Tool_146, Rotor_Pocket_17_3, Rotor_Pocket_23_3, Rotor_Pocket_31_3, Rotor_Pocket_9_3: 22cel
  L1_1Magnet2N1_1, L1_1Magnet1N1_1, L2_1Magnet2N1_1, L2_1Magnet1N1_1, Ph1_P2_C1_1, Ph1_P2_C5_1, Ph1_P2_C9_1, Ph1_P2_C13_1, Ph1_P2_C17_1, Ph1_P2_C21_1, Ph2_P2_C2_1, Ph2_P2_C6_1, Ph2_P2_C10_1, Ph2_P2_C14_1, Ph2_P2_C18_1, Ph2_P2_C22_1, Ph3_P1_C2_1, Ph3_P1_C6_1, Ph3_P1_C10_1, Ph3_P1_C14_1, Ph3_P1_C18_1, Ph3_P1_C22_1, Ph1_P1_C1_2, Ph1_P1_C5_2, Ph1_P1_C9_2, Ph1_P1_C13_2, Ph1_P1_C17_2, Ph1_P1_C21_2, Ph2_P1_C4_2, Ph2_P1_C8_2, Ph2_P1_C12_2, Ph2_P1_C16_2, Ph2_P1_C20_2, Ph2_P1_C24_2, Ph3_P2_C3_2, Ph3_P2_C7_2, Ph3_P2_C11_2, Ph3_P2_C15_2, Ph3_P2_C19_2, Ph3_P2_C23_2: 80cel
setups:
  MySetupAuto: Transient NonlinearSolverResidual=1e-08 ScalarPotential="Second Order" StopTime=1/StatorFrequency*1Hz*1s*PeriodMultiplier TimeStep=2000000ns OutputPerObjectCoreLoss OutputPerObjectSolidLoss InitialTimeStep=0.002s MinTimeStep=0.001s MaxTimeStep=0.003s TimeStepErrTolerance=0.0001
optimetrics:
  Optimetrics_PWM: Parametric InterpolationPoints=0 Sim._Setups=[MySetupAuto]
    sweep AAA: 1.0
    sweep MachineRPM: 15000rpm
    sweep PhaseAdvance: 79.41244351deg
    sweep IPeak: 231.129587A
    sweep PhaseVoltagePeak: 424.43247V
    sweep phiV: 64.123295deg
    table edits: add(2.0, 15000rpm, 75.66628551deg, 308.3753812A, 427.8586561825099V, 43.55505498830011deg) add(3.0, 15000rpm, 75.39984866deg, 411.7977408A, 432.06131421813944V, 24.376084333592022deg) add(4.0, 15000rpm, 77.59084809deg, 578.0743934A, 434.8190624345495V, -1.2762446883519252deg) add(5.0, 15000rpm, 78.96214049deg, 645.8155811A, 432.1161511857185V, -11.562128458892015deg)
output variables:
  ThetaED = ((pi * MachineRPM/1rpm*NumPoles / 60*time)) + pi
  Id_peak = 2/3*(Current(WG_Ph1_P1)*cos(ThetaED)+Current(WG_Ph2_P1)*cos(ThetaED - 120deg)+Current(WG_Ph3_P1)*cos(ThetaED - 240deg))
  Iq_peak = 2/3*(Current(WG_Ph1_P1)*-sin(ThetaED)+Current(WG_Ph2_P1)*-sin(ThetaED - 120deg)+Current(WG_Ph3_P1)*-sin(ThetaED - 240deg))
  PsiD = 2/3*(FluxLinkage(WG_Ph1_P1)*cos(ThetaED)+FluxLinkage(WG_Ph2_P1)*cos(ThetaED - 120deg)+FluxLinkage(WG_Ph3_P1)*cos(ThetaED - 240deg))
  PsiQ = 2/3*(FluxLinkage(WG_Ph1_P1)*-sin(ThetaED)+FluxLinkage(WG_Ph2_P1)*-sin(ThetaED - 120deg)+FluxLinkage(WG_Ph3_P1)*-sin(ThetaED - 240deg))
  TorqueDQ = 3/2*NumPoles/2*(PsiD*Iq_peak - PsiQ*Id_peak)
  StatorHy = HysteresisLoss(Stator_1) + HysteresisLoss(Stator_2)
  StatorEddy = EddyCurrentLoss(Stator_1) + EddyCurrentLoss(Stator_2)
  RotorHy = HysteresisLoss(Rotor_1) + HysteresisLoss(Rotor_2) + HysteresisLoss(Rotor_3)
  RotorEddy = EddyCurrentLoss(Rotor_1) + EddyCurrentLoss(Rotor_2) + EddyCurrentLoss(Rotor_3)
  MagLoss = SolidLoss(L1_1Magnet1N1_1) + SolidLoss(L1_1Magnet2N1_1) + SolidLoss(L2_1Magnet1N1_1) + SolidLoss(L2_1Magnet2N1_1)
  WindingLoss = PerWindingSolidLoss(WG_Ph1_P1) + PerWindingSolidLoss(WG_Ph2_P1) + PerWindingSolidLoss(WG_Ph3_P1)

design Sinusoidal_Current (Maxwell 2D, Transient, XY geometry, model units mm)
options: ModelDepth=Magnetic_Axial_Length
variables:
  AAA = 1000
  DiaGap = 142.54mm
  DiaStatorYoke = 198mm
  DiaOuter = 198mm
  Airgap = 1mm
  StatorSkewAngle = 0deg
  Model_Length = 0mm
  Stator_Lam_Length = 0mm
  SlotNumber_Stator = 48
  SlotType_Stator = 3
  Hs0_Stator = 1mm
  Hs1_Stator = 0.28212317mm
  Hs2_Stator = 12.551463mm
  Bs0_Stator = 1.43mm
  Bs1_Stator = 4.63mm
  Bs2_Stator = 4.63mm
  Rs_Stator = 0mm
  FilletType_Stator = 1
  Magnetic_Axial_Length = 150mm
  Layers = 6
  ParallelPaths = 2
  WireWidth = 3.711mm
  WireThick = 1.686mm
  WireRad = 0.3mm
  LayerGap = 0.35mm
  SpanExt_F = 40.095067mm
  SpanExt_R = 32.973924mm
  DiaGap_Hairpin = 142.37546mm
  WdgExt_Avg = 5mm
  HalfAxial = 0
  SymmetryFactor = 8
  SegAngle = 0deg
  SegAngle_Coil_Armature = 10deg
  NumPoles = 8
  IPeak = 650.53824A
  PhaseAdvance = 43.33deg
  MachineRPM = 750rpm
  Vpeak = 0V
  MaxPhasorAngle = 120deg
  DriveOffsetED = 30deg
  InitialPositionMD = DriveOffsetED / (NumPoles/2)
  StatorFrequency = NumPoles/2*MachineRPM/1rpm/60*1Hz
  PeriodMultiplier = 1
  NumTorquePointsPerCycle = 30
geometry:
  Stator_2 [NO18-1160_180C_SF0.97] = user_primitive(RMxprt/VentSlotCore.dll, DiaGap=DiaGap, DiaYoke=DiaStatorYoke, Length=Stator_Lam_Length, Skew=StatorSkewAngle, Slots=SlotNumber_Stator, SlotType=SlotType_Stator, Hs0=Hs0_Stator, Hs01=0mm, Hs1=Hs1_Stator, Hs2=12.551463mm, Bs0=Bs0_Stator, Bs1=4.63mm, Bs2=4.63mm, Rs=Rs_Stator, FilletType=FilletType_Stator, HalfSlot=0, VentHoles=0, HoleDiaIn=0mm, HoleDiaOut=0mm, HoleLocIn=0mm, HoleLocOut=0mm, VentDucts=0, DuctWidth=0mm, DuctPitch=0mm, SegAngle=SegAngle, LenRegion=0mm, InfoCore=0)
  Rotor_1 [NO18-1160_140C_SF0.97] = circle(normal=Z, centre=(0mm, 0mm, 0mm), radius=70.27mm)
  Rotor_Subtract_10 = circle(normal=Z, centre=(0mm, 0mm, 0mm), radius=23.455mm)
  Rotor_1.subtract(Rotor_Subtract_10)
  Rotor_Pocket_9 [vacuum] = polyline(z=0mm, xy in mm: (45.5148, 22.4775) (46.0306, 21.021) (47.5588, 20.7927) (49.4755, 21.5866) (50.0589, 22.0183) (50.3714, 22.6734) (50.4107, 22.8664) (54.1907, 41.4458) (54.3596, 42.2762) (54.352, 42.7126) (54.1605, 43.1049) (53.2056, 44.2782) (52.2253, 45.4304) (51.8654, 45.6019) (51.4945, 45.4558) (50.6239, 44.5852) (50.4726, 44.4083) (50.3504, 44.2102) (49.7597, 43.0607) (49.6785, 42.8721) (49.6239, 42.6741) (49.5654, 42.3868) (45.6857, 23.3175) (45.5148, 22.4775), closed, covered, Arc from point 0 over 3, Arc from point 3 over 3, Arc from point 8 over 3, Arc from point 10 over 3, Arc from point 12 over 3, Arc from point 15 over 3, Arc from point 18 over 3)
  coordinate_system CS_L1_1Magnet2N1_1 = origin=(50.086083mm, 32.606724mm, 0mm) x=(1.1912749mm, -0.24236761mm, 0mm) y=(0.24236761mm, 1.1912749mm, 0mm)
  L1_1Magnet2N1_1 [N42EH_20C [ref. Temp]_2D3DFactMagnet, oriented by CS_L1_1Magnet2N1_1] = polyline(z=0mm, xy in mm: (53.8004, 42.0354) (50.3511, 42.7372) (49.9754, 42.6642) (49.7614, 42.3469) (45.9814, 23.7676) (46.0544, 23.3919) (46.3717, 23.1779) (49.821, 22.4761) (50.1967, 22.5492) (50.4107, 22.8664) (54.1907, 41.4458) (54.1177, 41.8214) (53.8004, 42.0354), closed, covered, Arc from point 1 over 3, Arc from point 4 over 3, Arc from point 7 over 3, Arc from point 10 over 3)
  Rotor_Pocket_17 [vacuum] = polyline(z=0mm, xy in mm: (48.7926, 15.8167) (65.0201, 5.076) (65.2645, 4.9142) (65.4432, 4.8128) (65.6339, 4.7368) (66.8645, 4.3417) (67.0909, 4.288) (67.323, 4.27) (68.5542, 4.27) (68.9198, 4.4289) (69.053, 4.8047) (68.9315, 6.3125) (68.7771, 7.8174) (68.6351, 8.2302) (68.3318, 8.5442) (67.6252, 9.0119) (51.8147, 19.4767) (51.6505, 19.5854) (50.9663, 19.8277) (50.2485, 19.7204) (48.3318, 18.9264) (47.4127, 17.6844) (48.0779, 16.2898) (48.7926, 15.8167), closed, covered, Arc from point 2 over 3, Arc from point 5 over 3, Arc from point 8 over 3, Arc from point 10 over 3, Arc from point 12 over 3, Arc from point 17 over 3, Arc from point 20 over 3)
  coordinate_system CS_L1_1Magnet1N1_1 = origin=(58.472644mm, 12.359773mm, 0mm) x=(0.67097875mm, 1.0137383mm, 0mm) y=(-1.0137383mm, 0.67097875mm, 0mm)
  L1_1Magnet1N1_1 [N42EH_20C [ref. Temp]_2D3DFactMagnet, oriented by CS_L1_1Magnet1N1_1] = polyline(z=0mm, xy in mm: (65.8234, 5.3838) (67.7662, 8.319) (67.8392, 8.6947) (67.6252, 9.0119) (51.8147, 19.4767) (51.4391, 19.5497) (51.1218, 19.3357) (49.179, 16.4004) (49.106, 16.0248) (49.32, 15.7075) (65.1305, 5.2428) (65.5061, 5.1698) (65.8234, 5.3838), closed, covered, Arc from point 1 over 3, Arc from point 4 over 3, Arc from point 7 over 3, Arc from point 10 over 3)
  Rotor_Pocket_23 [vacuum] = polyline(z=0mm, xy in mm: (55.8125, 36.4691) (55.8337, 36.2755) (55.8797, 36.0864) (55.9706, 35.7962) (59.0002, 26.1289) (59.625, 25.4146) (60.5737, 25.3935) (61.4274, 25.7471) (62.0006, 26.2953) (62.0535, 27.0867) (59.0242, 36.7531) (58.7793, 37.5344) (58.7399, 37.6359) (58.6873, 37.7312) (57.9666, 38.8293) (57.2254, 39.9136) (56.9069, 40.098) (56.561, 39.9723) (56.1634, 39.5747) (55.826, 39.0575) (55.7255, 38.4482) (55.8125, 36.4691), closed, covered, Arc from point 0 over 3, Arc from point 4 over 3, Arc from point 7 over 3, Arc from point 11 over 3, Arc from point 13 over 3, Arc from point 15 over 3, Arc from point 18 over 3)
  coordinate_system CS_L2_1Magnet2N1_1 = origin=(59.083666mm, 31.463921mm, 0mm) x=(1.1600509mm, 0.36353791mm, 0mm) y=(-0.36353791mm, 1.1600509mm, 0mm)
  L2_1Magnet2N1_1 [N42EH_20C [ref. Temp]_2D3DFactMagnet, oriented by CS_L2_1Magnet2N1_1] = polyline(z=0mm, xy in mm: (58.3975, 37.0807) (56.4414, 36.4677) (56.1478, 36.2222) (56.1138, 35.8411) (59.143, 26.1746) (59.3885, 25.881) (59.7697, 25.847) (61.7259, 26.46) (62.0195, 26.7055) (62.0535, 27.0867) (59.0242, 36.7531) (58.7787, 37.0467) (58.3975, 37.0807), closed, covered, Arc from point 1 over 3, Arc from point 4 over 3, Arc from point 7 over 3, Arc from point 10 over 3)
  Rotor_Pocket_31 [vacuum] = polyline(z=0mm, xy in mm: (64.889, 14.2654) (65.0298, 13.996) (65.131, 13.8296) (65.2529, 13.6778) (66.5909, 12.2169) (67.0928, 11.8571) (67.6971, 11.7299) (68.2594, 11.73) (68.5929, 11.8856) (68.6877, 12.2413) (68.4451, 13.5321) (68.1782, 14.8182) (68.148, 14.9227) (68.1041, 15.0224) (67.7248, 15.748) (63.0316, 24.7252) (62.4346, 25.2474) (61.6417, 25.2297) (60.788, 24.8761) (60.1321, 24.1903) (60.1954, 23.2434) (64.889, 14.2654), closed, covered, Arc from point 1 over 3, Arc from point 4 over 3, Arc from point 7 over 3, Arc from point 9 over 3, Arc from point 11 over 3, Arc from point 15 over 3, Arc from point 18 over 3)
  coordinate_system CS_L2_1Magnet1N1_1 = origin=(64.026812mm, 19.530109mm, 0mm) x=(1.07734mm, 0.56321972mm, 0mm) y=(-0.56321972mm, 1.07734mm, 0mm)
  L2_1Magnet1N1_1 [N42EH_20C [ref. Temp]_2D3DFactMagnet, oriented by CS_L2_1Magnet1N1_1] = polyline(z=0mm, xy in mm: (65.6966, 14.1235) (67.5134, 15.0732) (67.7588, 15.3668) (67.7248, 15.748) (63.0316, 24.7252) (62.738, 24.9707) (62.3569, 24.9367) (60.5402, 23.9869) (60.2947, 23.6933) (60.3287, 23.3122) (65.0219, 14.3349) (65.3155, 14.0894) (65.6966, 14.1235), closed, covered, Arc from point 1 over 3, Arc from point 4 over 3, Arc from point 7 over 3, Arc from point 10 over 3)
  Shaft [Stahl 37_80C_2D3DFactShaft] = circle(normal=Z, centre=(0mm, 0mm, 0mm), radius=23.455mm)
  Ph1_P1_C1_1 = user_primitive(RMxprt/HairpinCoil.dll, DiaGap=DiaGap_Hairpin, DiaYoke=DiaStatorYoke, Length=Stator_Lam_Length, Skew=StatorSkewAngle, Slots=SlotNumber_Stator, SlotType=SlotType_Stator, Hs0=Hs0_Stator, Hs1=Hs1_Stator, Hs2=Hs2_Stator, Bs0=Bs0_Stator, Bs1=Bs1_Stator, Bs2=Bs2_Stator, Rs=Rs_Stator, FilletType=1, Layers=Layers, CoilPitch=-6, EndExt=WdgExt_Avg, SpanExt/SpanGap=SpanExt_F, SegAngle=SegAngle_Coil_Armature, 1stPitch=0, 2ndPitch=6, 2ndSpanExt/SpanGap=SpanExt_R, WireWidth=WireWidth, WireThick=WireThick, WireRad=WireRad, LayerSetGap=LayerGap, LayerSetIdx=0, LayerGap=LayerGap, WindingType=1, CoilSetIdx=0, LenRegion=Model_Length, InfoCoil=4)
  Ph1_P1_C1_1.rotate(axis=Z, angle=45deg)
  Ph1_P1_C5_1 = user_primitive(RMxprt/HairpinCoil.dll, DiaGap=DiaGap_Hairpin, DiaYoke=DiaStatorYoke, Length=Stator_Lam_Length, Skew=StatorSkewAngle, Slots=SlotNumber_Stator, SlotType=SlotType_Stator, Hs0=Hs0_Stator, Hs1=Hs1_Stator, Hs2=Hs2_Stator, Bs0=Bs0_Stator, Bs1=Bs1_Stator, Bs2=Bs2_Stator, Rs=Rs_Stator, FilletType=1, Layers=Layers, CoilPitch=-6, EndExt=WdgExt_Avg, SpanExt/SpanGap=SpanExt_F, SegAngle=SegAngle_Coil_Armature, 1stPitch=0, 2ndPitch=6, 2ndSpanExt/SpanGap=SpanExt_R, WireWidth=WireWidth, WireThick=WireThick, WireRad=WireRad, LayerSetGap=LayerGap, LayerSetIdx=1, LayerGap=LayerGap, WindingType=1, CoilSetIdx=0, LenRegion=Model_Length, InfoCoil=4)
  Ph1_P1_C5_1.rotate(axis=Z, angle=52.5deg)
  Ph1_P1_C9_1 = user_primitive(RMxprt/HairpinCoil.dll, DiaGap=DiaGap_Hairpin, DiaYoke=DiaStatorYoke, Length=Stator_Lam_Length, Skew=StatorSkewAngle, Slots=SlotNumber_Stator, SlotType=SlotType_Stator, Hs0=Hs0_Stator, Hs1=Hs1_Stator, Hs2=Hs2_Stator, Bs0=Bs0_Stator, Bs1=Bs1_Stator, Bs2=Bs2_Stator, Rs=Rs_Stator, FilletType=1, Layers=Layers, CoilPitch=-6, EndExt=WdgExt_Avg, SpanExt/SpanGap=SpanExt_F, SegAngle=SegAngle_Coil_Armature, 1stPitch=0, 2ndPitch=6, 2ndSpanExt/SpanGap=SpanExt_R, WireWidth=WireWidth, WireThick=WireThick, WireRad=WireRad, LayerSetGap=LayerGap, LayerSetIdx=2, LayerGap=LayerGap, WindingType=1, CoilSetIdx=0, LenRegion=Model_Length, InfoCoil=4)
  Ph1_P1_C9_1.rotate(axis=Z, angle=45deg)
  Ph1_P1_C13_1 = user_primitive(RMxprt/HairpinCoil.dll, DiaGap=DiaGap_Hairpin, DiaYoke=DiaStatorYoke, Length=Stator_Lam_Length, Skew=StatorSkewAngle, Slots=SlotNumber_Stator, SlotType=SlotType_Stator, Hs0=Hs0_Stator, Hs1=Hs1_Stator, Hs2=Hs2_Stator, Bs0=Bs0_Stator, Bs1=Bs1_Stator, Bs2=Bs2_Stator, Rs=Rs_Stator, FilletType=1, Layers=Layers, CoilPitch=-6, EndExt=WdgExt_Avg, SpanExt/SpanGap=SpanExt_F, SegAngle=SegAngle_Coil_Armature, 1stPitch=0, 2ndPitch=6, 2ndSpanExt/SpanGap=SpanExt_R, WireWidth=WireWidth, WireThick=WireThick, WireRad=WireRad, LayerSetGap=LayerGap, LayerSetIdx=0, LayerGap=LayerGap, WindingType=1, CoilSetIdx=0, LenRegion=Model_Length, InfoCoil=4)
  Ph1_P1_C13_1.rotate(axis=Z, angle=52.5deg)
  Ph1_P1_C17_1 = user_primitive(RMxprt/HairpinCoil.dll, DiaGap=DiaGap_Hairpin, DiaYoke=DiaStatorYoke, Length=Stator_Lam_Length, Skew=StatorSkewAngle, Slots=SlotNumber_Stator, SlotType=SlotType_Stator, Hs0=Hs0_Stator, Hs1=Hs1_Stator, Hs2=Hs2_Stator, Bs0=Bs0_Stator, Bs1=Bs1_Stator, Bs2=Bs2_Stator, Rs=Rs_Stator, FilletType=1, Layers=Layers, CoilPitch=-6, EndExt=WdgExt_Avg, SpanExt/SpanGap=SpanExt_F, SegAngle=SegAngle_Coil_Armature, 1stPitch=0, 2ndPitch=6, 2ndSpanExt/SpanGap=SpanExt_R, WireWidth=WireWidth, WireThick=WireThick, WireRad=WireRad, LayerSetGap=LayerGap, LayerSetIdx=1, LayerGap=LayerGap, WindingType=1, CoilSetIdx=0, LenRegion=Model_Length, InfoCoil=4)
  Ph1_P1_C17_1.rotate(axis=Z, angle=45deg)
  Ph1_P1_C21_1 = user_primitive(RMxprt/HairpinCoil.dll, DiaGap=DiaGap_Hairpin, DiaYoke=DiaStatorYoke, Length=Stator_Lam_Length, Skew=StatorSkewAngle, Slots=SlotNumber_Stator, SlotType=SlotType_Stator, Hs0=Hs0_Stator, Hs1=Hs1_Stator, Hs2=Hs2_Stator, Bs0=Bs0_Stator, Bs1=Bs1_Stator, Bs2=Bs2_Stator, Rs=Rs_Stator, FilletType=1, Layers=Layers, CoilPitch=-6, EndExt=WdgExt_Avg, SpanExt/SpanGap=SpanExt_F, SegAngle=SegAngle_Coil_Armature, 1stPitch=0, 2ndPitch=6, 2ndSpanExt/SpanGap=SpanExt_R, WireWidth=WireWidth, WireThick=WireThick, WireRad=WireRad, LayerSetGap=LayerGap, LayerSetIdx=2, LayerGap=LayerGap, WindingType=1, CoilSetIdx=0, LenRegion=Model_Length, InfoCoil=4)
  Ph1_P1_C21_1.rotate(axis=Z, angle=52.5deg)
  Ph1_P2_C1_1 [Copper (Pure)_20C [ref. Temp]] = user_primitive(RMxprt/HairpinCoil.dll, DiaGap=DiaGap_Hairpin, DiaYoke=DiaStatorYoke, Length=Stator_Lam_Length, Skew=StatorSkewAngle, Slots=SlotNumber_Stator, SlotType=SlotType_Stator, Hs0=Hs0_Stator, Hs1=Hs1_Stator, Hs2=Hs2_Stator, Bs0=Bs0_Stator, Bs1=Bs1_Stator, Bs2=Bs2_Stator, Rs=Rs_Stator, FilletType=1, Layers=Layers, CoilPitch=-6, EndExt=WdgExt_Avg, SpanExt/SpanGap=SpanExt_F, SegAngle=SegAngle_Coil_Armature, 1stPitch=0, 2ndPitch=6, 2ndSpanExt/SpanGap=SpanExt_R, WireWidth=WireWidth, WireThick=WireThick, WireRad=WireRad, LayerSetGap=LayerGap, LayerSetIdx=0, LayerGap=LayerGap, WindingType=1, CoilSetIdx=0, LenRegion=Model_Length, InfoCoil=4)
  Ph1_P2_C1_1.rotate(axis=Z, angle=0deg)
  Ph1_P2_C5_1 [Copper (Pure)_20C [ref. Temp]] = user_primitive(RMxprt/HairpinCoil.dll, DiaGap=DiaGap_Hairpin, DiaYoke=DiaStatorYoke, Length=Stator_Lam_Length, Skew=StatorSkewAngle, Slots=SlotNumber_Stator, SlotType=SlotType_Stator, Hs0=Hs0_Stator, Hs1=Hs1_Stator, Hs2=Hs2_Stator, Bs0=Bs0_Stator, Bs1=Bs1_Stator, Bs2=Bs2_Stator, Rs=Rs_Stator, FilletType=1, Layers=Layers, CoilPitch=-6, EndExt=WdgExt_Avg, SpanExt/SpanGap=SpanExt_F, SegAngle=SegAngle_Coil_Armature, 1stPitch=0, 2ndPitch=6, 2ndSpanExt/SpanGap=SpanExt_R, WireWidth=WireWidth, WireThick=WireThick, WireRad=WireRad, LayerSetGap=LayerGap, LayerSetIdx=1, LayerGap=LayerGap, WindingType=1, CoilSetIdx=0, LenRegion=Model_Length, InfoCoil=4)
  Ph1_P2_C5_1.rotate(axis=Z, angle=7.5deg)
  Ph1_P2_C9_1 [Copper (Pure)_20C [ref. Temp]] = user_primitive(RMxprt/HairpinCoil.dll, DiaGap=DiaGap_Hairpin, DiaYoke=DiaStatorYoke, Length=Stator_Lam_Length, Skew=StatorSkewAngle, Slots=SlotNumber_Stator, SlotType=SlotType_Stator, Hs0=Hs0_Stator, Hs1=Hs1_Stator, Hs2=Hs2_Stator, Bs0=Bs0_Stator, Bs1=Bs1_Stator, Bs2=Bs2_Stator, Rs=Rs_Stator, FilletType=1, Layers=Layers, CoilPitch=-6, EndExt=WdgExt_Avg, SpanExt/SpanGap=SpanExt_F, SegAngle=SegAngle_Coil_Armature, 1stPitch=0, 2ndPitch=6, 2ndSpanExt/SpanGap=SpanExt_R, WireWidth=WireWidth, WireThick=WireThick, WireRad=WireRad, LayerSetGap=LayerGap, LayerSetIdx=2, LayerGap=LayerGap, WindingType=1, CoilSetIdx=0, LenRegion=Model_Length, InfoCoil=4)
  Ph1_P2_C9_1.rotate(axis=Z, angle=0deg)
  Ph1_P2_C13_1 [Copper (Pure)_20C [ref. Temp]] = user_primitive(RMxprt/HairpinCoil.dll, DiaGap=DiaGap_Hairpin, DiaYoke=DiaStatorYoke, Length=Stator_Lam_Length, Skew=StatorSkewAngle, Slots=SlotNumber_Stator, SlotType=SlotType_Stator, Hs0=Hs0_Stator, Hs1=Hs1_Stator, Hs2=Hs2_Stator, Bs0=Bs0_Stator, Bs1=Bs1_Stator, Bs2=Bs2_Stator, Rs=Rs_Stator, FilletType=1, Layers=Layers, CoilPitch=-6, EndExt=WdgExt_Avg, SpanExt/SpanGap=SpanExt_F, SegAngle=SegAngle_Coil_Armature, 1stPitch=0, 2ndPitch=6, 2ndSpanExt/SpanGap=SpanExt_R, WireWidth=WireWidth, WireThick=WireThick, WireRad=WireRad, LayerSetGap=LayerGap, LayerSetIdx=0, LayerGap=LayerGap, WindingType=1, CoilSetIdx=0, LenRegion=Model_Length, InfoCoil=4)
  Ph1_P2_C13_1.rotate(axis=Z, angle=7.5deg)
  Ph1_P2_C17_1 [Copper (Pure)_20C [ref. Temp]] = user_primitive(RMxprt/HairpinCoil.dll, DiaGap=DiaGap_Hairpin, DiaYoke=DiaStatorYoke, Length=Stator_Lam_Length, Skew=StatorSkewAngle, Slots=SlotNumber_Stator, SlotType=SlotType_Stator, Hs0=Hs0_Stator, Hs1=Hs1_Stator, Hs2=Hs2_Stator, Bs0=Bs0_Stator, Bs1=Bs1_Stator, Bs2=Bs2_Stator, Rs=Rs_Stator, FilletType=1, Layers=Layers, CoilPitch=-6, EndExt=WdgExt_Avg, SpanExt/SpanGap=SpanExt_F, SegAngle=SegAngle_Coil_Armature, 1stPitch=0, 2ndPitch=6, 2ndSpanExt/SpanGap=SpanExt_R, WireWidth=WireWidth, WireThick=WireThick, WireRad=WireRad, LayerSetGap=LayerGap, LayerSetIdx=1, LayerGap=LayerGap, WindingType=1, CoilSetIdx=0, LenRegion=Model_Length, InfoCoil=4)
  Ph1_P2_C17_1.rotate(axis=Z, angle=0deg)
  Ph1_P2_C21_1 [Copper (Pure)_20C [ref. Temp]] = user_primitive(RMxprt/HairpinCoil.dll, DiaGap=DiaGap_Hairpin, DiaYoke=DiaStatorYoke, Length=Stator_Lam_Length, Skew=StatorSkewAngle, Slots=SlotNumber_Stator, SlotType=SlotType_Stator, Hs0=Hs0_Stator, Hs1=Hs1_Stator, Hs2=Hs2_Stator, Bs0=Bs0_Stator, Bs1=Bs1_Stator, Bs2=Bs2_Stator, Rs=Rs_Stator, FilletType=1, Layers=Layers, CoilPitch=-6, EndExt=WdgExt_Avg, SpanExt/SpanGap=SpanExt_F, SegAngle=SegAngle_Coil_Armature, 1stPitch=0, 2ndPitch=6, 2ndSpanExt/SpanGap=SpanExt_R, WireWidth=WireWidth, WireThick=WireThick, WireRad=WireRad, LayerSetGap=LayerGap, LayerSetIdx=2, LayerGap=LayerGap, WindingType=1, CoilSetIdx=0, LenRegion=Model_Length, InfoCoil=4)
  Ph1_P2_C21_1.rotate(axis=Z, angle=7.5deg)
  Ph2_P1_C4_1 = user_primitive(RMxprt/HairpinCoil.dll, DiaGap=DiaGap_Hairpin, DiaYoke=DiaStatorYoke, Length=Stator_Lam_Length, Skew=StatorSkewAngle, Slots=SlotNumber_Stator, SlotType=SlotType_Stator, Hs0=Hs0_Stator, Hs1=Hs1_Stator, Hs2=Hs2_Stator, Bs0=Bs0_Stator, Bs1=Bs1_Stator, Bs2=Bs2_Stator, Rs=Rs_Stator, FilletType=1, Layers=Layers, CoilPitch=-6, EndExt=WdgExt_Avg, SpanExt/SpanGap=SpanExt_F, SegAngle=SegAngle_Coil_Armature, 1stPitch=0, 2ndPitch=6, 2ndSpanExt/SpanGap=SpanExt_R, WireWidth=WireWidth, WireThick=WireThick, WireRad=WireRad, LayerSetGap=LayerGap, LayerSetIdx=0, LayerGap=LayerGap, WindingType=1, CoilSetIdx=0, LenRegion=Model_Length, InfoCoil=4)
  Ph2_P1_C4_1.rotate(axis=Z, angle=75deg)
  Ph2_P1_C8_1 = user_primitive(RMxprt/HairpinCoil.dll, DiaGap=DiaGap_Hairpin, DiaYoke=DiaStatorYoke, Length=Stator_Lam_Length, Skew=StatorSkewAngle, Slots=SlotNumber_Stator, SlotType=SlotType_Stator, Hs0=Hs0_Stator, Hs1=Hs1_Stator, Hs2=Hs2_Stator, Bs0=Bs0_Stator, Bs1=Bs1_Stator, Bs2=Bs2_Stator, Rs=Rs_Stator, FilletType=1, Layers=Layers, CoilPitch=-6, EndExt=WdgExt_Avg, SpanExt/SpanGap=SpanExt_F, SegAngle=SegAngle_Coil_Armature, 1stPitch=0, 2ndPitch=6, 2ndSpanExt/SpanGap=SpanExt_R, WireWidth=WireWidth, WireThick=WireThick, WireRad=WireRad, LayerSetGap=LayerGap, LayerSetIdx=1, LayerGap=LayerGap, WindingType=1, CoilSetIdx=0, LenRegion=Model_Length, InfoCoil=4)
  Ph2_P1_C8_1.rotate(axis=Z, angle=82.5deg)
  Ph2_P1_C12_1 = user_primitive(RMxprt/HairpinCoil.dll, DiaGap=DiaGap_Hairpin, DiaYoke=DiaStatorYoke, Length=Stator_Lam_Length, Skew=StatorSkewAngle, Slots=SlotNumber_Stator, SlotType=SlotType_Stator, Hs0=Hs0_Stator, Hs1=Hs1_Stator, Hs2=Hs2_Stator, Bs0=Bs0_Stator, Bs1=Bs1_Stator, Bs2=Bs2_Stator, Rs=Rs_Stator, FilletType=1, Layers=Layers, CoilPitch=-6, EndExt=WdgExt_Avg, SpanExt/SpanGap=SpanExt_F, SegAngle=SegAngle_Coil_Armature, 1stPitch=0, 2ndPitch=6, 2ndSpanExt/SpanGap=SpanExt_R, WireWidth=WireWidth, WireThick=WireThick, WireRad=WireRad, LayerSetGap=LayerGap, LayerSetIdx=2, LayerGap=LayerGap, WindingType=1, CoilSetIdx=0, LenRegion=Model_Length, InfoCoil=4)
  Ph2_P1_C12_1.rotate(axis=Z, angle=75deg)
  Ph2_P1_C16_1 = user_primitive(RMxprt/HairpinCoil.dll, DiaGap=DiaGap_Hairpin, DiaYoke=DiaStatorYoke, Length=Stator_Lam_Length, Skew=StatorSkewAngle, Slots=SlotNumber_Stator, SlotType=SlotType_Stator, Hs0=Hs0_Stator, Hs1=Hs1_Stator, Hs2=Hs2_Stator, Bs0=Bs0_Stator, Bs1=Bs1_Stator, Bs2=Bs2_Stator, Rs=Rs_Stator, FilletType=1, Layers=Layers, CoilPitch=-6, EndExt=WdgExt_Avg, SpanExt/SpanGap=SpanExt_F, SegAngle=SegAngle_Coil_Armature, 1stPitch=0, 2ndPitch=6, 2ndSpanExt/SpanGap=SpanExt_R, WireWidth=WireWidth, WireThick=WireThick, WireRad=WireRad, LayerSetGap=LayerGap, LayerSetIdx=0, LayerGap=LayerGap, WindingType=1, CoilSetIdx=0, LenRegion=Model_Length, InfoCoil=4)
  Ph2_P1_C16_1.rotate(axis=Z, angle=82.5deg)
  Ph2_P1_C20_1 = user_primitive(RMxprt/HairpinCoil.dll, DiaGap=DiaGap_Hairpin, DiaYoke=DiaStatorYoke, Length=Stator_Lam_Length, Skew=StatorSkewAngle, Slots=SlotNumber_Stator, SlotType=SlotType_Stator, Hs0=Hs0_Stator, Hs1=Hs1_Stator, Hs2=Hs2_Stator, Bs0=Bs0_Stator, Bs1=Bs1_Stator, Bs2=Bs2_Stator, Rs=Rs_Stator, FilletType=1, Layers=Layers, CoilPitch=-6, EndExt=WdgExt_Avg, SpanExt/SpanGap=SpanExt_F, SegAngle=SegAngle_Coil_Armature, 1stPitch=0, 2ndPitch=6, 2ndSpanExt/SpanGap=SpanExt_R, WireWidth=WireWidth, WireThick=WireThick, WireRad=WireRad, LayerSetGap=LayerGap, LayerSetIdx=1, LayerGap=LayerGap, WindingType=1, CoilSetIdx=0, LenRegion=Model_Length, InfoCoil=4)
  Ph2_P1_C20_1.rotate(axis=Z, angle=75deg)
  Ph2_P1_C24_1 = user_primitive(RMxprt/HairpinCoil.dll, DiaGap=DiaGap_Hairpin, DiaYoke=DiaStatorYoke, Length=Stator_Lam_Length, Skew=StatorSkewAngle, Slots=SlotNumber_Stator, SlotType=SlotType_Stator, Hs0=Hs0_Stator, Hs1=Hs1_Stator, Hs2=Hs2_Stator, Bs0=Bs0_Stator, Bs1=Bs1_Stator, Bs2=Bs2_Stator, Rs=Rs_Stator, FilletType=1, Layers=Layers, CoilPitch=-6, EndExt=WdgExt_Avg, SpanExt/SpanGap=SpanExt_F, SegAngle=SegAngle_Coil_Armature, 1stPitch=0, 2ndPitch=6, 2ndSpanExt/SpanGap=SpanExt_R, WireWidth=WireWidth, WireThick=WireThick, WireRad=WireRad, LayerSetGap=LayerGap, LayerSetIdx=2, LayerGap=LayerGap, WindingType=1, CoilSetIdx=0, LenRegion=Model_Length, InfoCoil=4)
  Ph2_P1_C24_1.rotate(axis=Z, angle=82.5deg)
  Ph2_P2_C2_1 [Copper (Pure)_20C [ref. Temp]] = user_primitive(RMxprt/HairpinCoil.dll, DiaGap=DiaGap_Hairpin, DiaYoke=DiaStatorYoke, Length=Stator_Lam_Length, Skew=StatorSkewAngle, Slots=SlotNumber_Stator, SlotType=SlotType_Stator, Hs0=Hs0_Stator, Hs1=Hs1_Stator, Hs2=Hs2_Stator, Bs0=Bs0_Stator, Bs1=Bs1_Stator, Bs2=Bs2_Stator, Rs=Rs_Stator, FilletType=1, Layers=Layers, CoilPitch=-6, EndExt=WdgExt_Avg, SpanExt/SpanGap=SpanExt_F, SegAngle=SegAngle_Coil_Armature, 1stPitch=0, 2ndPitch=6, 2ndSpanExt/SpanGap=SpanExt_R, WireWidth=WireWidth, WireThick=WireThick, WireRad=WireRad, LayerSetGap=LayerGap, LayerSetIdx=0, LayerGap=LayerGap, WindingType=1, CoilSetIdx=0, LenRegion=Model_Length, InfoCoil=4)
  Ph2_P2_C2_1.rotate(axis=Z, angle=30deg)
  Ph2_P2_C6_1 [Copper (Pure)_20C [ref. Temp]] = user_primitive(RMxprt/HairpinCoil.dll, DiaGap=DiaGap_Hairpin, DiaYoke=DiaStatorYoke, Length=Stator_Lam_Length, Skew=StatorSkewAngle, Slots=SlotNumber_Stator, SlotType=SlotType_Stator, Hs0=Hs0_Stator, Hs1=Hs1_Stator, Hs2=Hs2_Stator, Bs0=Bs0_Stator, Bs1=Bs1_Stator, Bs2=Bs2_Stator, Rs=Rs_Stator, FilletType=1, Layers=Layers, CoilPitch=-6, EndExt=WdgExt_Avg, SpanExt/SpanGap=SpanExt_F, SegAngle=SegAngle_Coil_Armature, 1stPitch=0, 2ndPitch=6, 2ndSpanExt/SpanGap=SpanExt_R, WireWidth=WireWidth, WireThick=WireThick, WireRad=WireRad, LayerSetGap=LayerGap, LayerSetIdx=1, LayerGap=LayerGap, WindingType=1, CoilSetIdx=0, LenRegion=Model_Length, InfoCoil=4)
  Ph2_P2_C6_1.rotate(axis=Z, angle=37.5deg)
  Ph2_P2_C10_1 [Copper (Pure)_20C [ref. Temp]] = user_primitive(RMxprt/HairpinCoil.dll, DiaGap=DiaGap_Hairpin, DiaYoke=DiaStatorYoke, Length=Stator_Lam_Length, Skew=StatorSkewAngle, Slots=SlotNumber_Stator, SlotType=SlotType_Stator, Hs0=Hs0_Stator, Hs1=Hs1_Stator, Hs2=Hs2_Stator, Bs0=Bs0_Stator, Bs1=Bs1_Stator, Bs2=Bs2_Stator, Rs=Rs_Stator, FilletType=1, Layers=Layers, CoilPitch=-6, EndExt=WdgExt_Avg, SpanExt/SpanGap=SpanExt_F, SegAngle=SegAngle_Coil_Armature, 1stPitch=0, 2ndPitch=6, 2ndSpanExt/SpanGap=SpanExt_R, WireWidth=WireWidth, WireThick=WireThick, WireRad=WireRad, LayerSetGap=LayerGap, LayerSetIdx=2, LayerGap=LayerGap, WindingType=1, CoilSetIdx=0, LenRegion=Model_Length, InfoCoil=4)
  Ph2_P2_C10_1.rotate(axis=Z, angle=30deg)
  Ph2_P2_C14_1 [Copper (Pure)_20C [ref. Temp]] = user_primitive(RMxprt/HairpinCoil.dll, DiaGap=DiaGap_Hairpin, DiaYoke=DiaStatorYoke, Length=Stator_Lam_Length, Skew=StatorSkewAngle, Slots=SlotNumber_Stator, SlotType=SlotType_Stator, Hs0=Hs0_Stator, Hs1=Hs1_Stator, Hs2=Hs2_Stator, Bs0=Bs0_Stator, Bs1=Bs1_Stator, Bs2=Bs2_Stator, Rs=Rs_Stator, FilletType=1, Layers=Layers, CoilPitch=-6, EndExt=WdgExt_Avg, SpanExt/SpanGap=SpanExt_F, SegAngle=SegAngle_Coil_Armature, 1stPitch=0, 2ndPitch=6, 2ndSpanExt/SpanGap=SpanExt_R, WireWidth=WireWidth, WireThick=WireThick, WireRad=WireRad, LayerSetGap=LayerGap, LayerSetIdx=0, LayerGap=LayerGap, WindingType=1, CoilSetIdx=0, LenRegion=Model_Length, InfoCoil=4)
  Ph2_P2_C14_1.rotate(axis=Z, angle=37.5deg)
  Ph2_P2_C18_1 [Copper (Pure)_20C [ref. Temp]] = user_primitive(RMxprt/HairpinCoil.dll, DiaGap=DiaGap_Hairpin, DiaYoke=DiaStatorYoke, Length=Stator_Lam_Length, Skew=StatorSkewAngle, Slots=SlotNumber_Stator, SlotType=SlotType_Stator, Hs0=Hs0_Stator, Hs1=Hs1_Stator, Hs2=Hs2_Stator, Bs0=Bs0_Stator, Bs1=Bs1_Stator, Bs2=Bs2_Stator, Rs=Rs_Stator, FilletType=1, Layers=Layers, CoilPitch=-6, EndExt=WdgExt_Avg, SpanExt/SpanGap=SpanExt_F, SegAngle=SegAngle_Coil_Armature, 1stPitch=0, 2ndPitch=6, 2ndSpanExt/SpanGap=SpanExt_R, WireWidth=WireWidth, WireThick=WireThick, WireRad=WireRad, LayerSetGap=LayerGap, LayerSetIdx=1, LayerGap=LayerGap, WindingType=1, CoilSetIdx=0, LenRegion=Model_Length, InfoCoil=4)
  Ph2_P2_C18_1.rotate(axis=Z, angle=30deg)
  Ph2_P2_C22_1 [Copper (Pure)_20C [ref. Temp]] = user_primitive(RMxprt/HairpinCoil.dll, DiaGap=DiaGap_Hairpin, DiaYoke=DiaStatorYoke, Length=Stator_Lam_Length, Skew=StatorSkewAngle, Slots=SlotNumber_Stator, SlotType=SlotType_Stator, Hs0=Hs0_Stator, Hs1=Hs1_Stator, Hs2=Hs2_Stator, Bs0=Bs0_Stator, Bs1=Bs1_Stator, Bs2=Bs2_Stator, Rs=Rs_Stator, FilletType=1, Layers=Layers, CoilPitch=-6, EndExt=WdgExt_Avg, SpanExt/SpanGap=SpanExt_F, SegAngle=SegAngle_Coil_Armature, 1stPitch=0, 2ndPitch=6, 2ndSpanExt/SpanGap=SpanExt_R, WireWidth=WireWidth, WireThick=WireThick, WireRad=WireRad, LayerSetGap=LayerGap, LayerSetIdx=2, LayerGap=LayerGap, WindingType=1, CoilSetIdx=0, LenRegion=Model_Length, InfoCoil=4)
  Ph2_P2_C22_1.rotate(axis=Z, angle=37.5deg)
  Ph3_P1_C2_1 [Copper (Pure)_20C [ref. Temp]] = user_primitive(RMxprt/HairpinCoil.dll, DiaGap=DiaGap_Hairpin, DiaYoke=DiaStatorYoke, Length=Stator_Lam_Length, Skew=StatorSkewAngle, Slots=SlotNumber_Stator, SlotType=SlotType_Stator, Hs0=Hs0_Stator, Hs1=Hs1_Stator, Hs2=Hs2_Stator, Bs0=Bs0_Stator, Bs1=Bs1_Stator, Bs2=Bs2_Stator, Rs=Rs_Stator, FilletType=1, Layers=Layers, CoilPitch=-6, EndExt=WdgExt_Avg, SpanExt/SpanGap=SpanExt_F, SegAngle=SegAngle_Coil_Armature, 1stPitch=0, 2ndPitch=6, 2ndSpanExt/SpanGap=SpanExt_R, WireWidth=WireWidth, WireThick=WireThick, WireRad=WireRad, LayerSetGap=LayerGap, LayerSetIdx=0, LayerGap=LayerGap, WindingType=1, CoilSetIdx=0, LenRegion=Model_Length, InfoCoil=4)
  Ph3_P1_C2_1.rotate(axis=Z, angle=15deg)
  Ph3_P1_C6_1 [Copper (Pure)_20C [ref. Temp]] = user_primitive(RMxprt/HairpinCoil.dll, DiaGap=DiaGap_Hairpin, DiaYoke=DiaStatorYoke, Length=Stator_Lam_Length, Skew=StatorSkewAngle, Slots=SlotNumber_Stator, SlotType=SlotType_Stator, Hs0=Hs0_Stator, Hs1=Hs1_Stator, Hs2=Hs2_Stator, Bs0=Bs0_Stator, Bs1=Bs1_Stator, Bs2=Bs2_Stator, Rs=Rs_Stator, FilletType=1, Layers=Layers, CoilPitch=-6, EndExt=WdgExt_Avg, SpanExt/SpanGap=SpanExt_F, SegAngle=SegAngle_Coil_Armature, 1stPitch=0, 2ndPitch=6, 2ndSpanExt/SpanGap=SpanExt_R, WireWidth=WireWidth, WireThick=WireThick, WireRad=WireRad, LayerSetGap=LayerGap, LayerSetIdx=1, LayerGap=LayerGap, WindingType=1, CoilSetIdx=0, LenRegion=Model_Length, InfoCoil=4)
  Ph3_P1_C6_1.rotate(axis=Z, angle=22.5deg)
  Ph3_P1_C10_1 [Copper (Pure)_20C [ref. Temp]] = user_primitive(RMxprt/HairpinCoil.dll, DiaGap=DiaGap_Hairpin, DiaYoke=DiaStatorYoke, Length=Stator_Lam_Length, Skew=StatorSkewAngle, Slots=SlotNumber_Stator, SlotType=SlotType_Stator, Hs0=Hs0_Stator, Hs1=Hs1_Stator, Hs2=Hs2_Stator, Bs0=Bs0_Stator, Bs1=Bs1_Stator, Bs2=Bs2_Stator, Rs=Rs_Stator, FilletType=1, Layers=Layers, CoilPitch=-6, EndExt=WdgExt_Avg, SpanExt/SpanGap=SpanExt_F, SegAngle=SegAngle_Coil_Armature, 1stPitch=0, 2ndPitch=6, 2ndSpanExt/SpanGap=SpanExt_R, WireWidth=WireWidth, WireThick=WireThick, WireRad=WireRad, LayerSetGap=LayerGap, LayerSetIdx=2, LayerGap=LayerGap, WindingType=1, CoilSetIdx=0, LenRegion=Model_Length, InfoCoil=4)
  Ph3_P1_C10_1.rotate(axis=Z, angle=15deg)
  Ph3_P1_C14_1 [Copper (Pure)_20C [ref. Temp]] = user_primitive(RMxprt/HairpinCoil.dll, DiaGap=DiaGap_Hairpin, DiaYoke=DiaStatorYoke, Length=Stator_Lam_Length, Skew=StatorSkewAngle, Slots=SlotNumber_Stator, SlotType=SlotType_Stator, Hs0=Hs0_Stator, Hs1=Hs1_Stator, Hs2=Hs2_Stator, Bs0=Bs0_Stator, Bs1=Bs1_Stator, Bs2=Bs2_Stator, Rs=Rs_Stator, FilletType=1, Layers=Layers, CoilPitch=-6, EndExt=WdgExt_Avg, SpanExt/SpanGap=SpanExt_F, SegAngle=SegAngle_Coil_Armature, 1stPitch=0, 2ndPitch=6, 2ndSpanExt/SpanGap=SpanExt_R, WireWidth=WireWidth, WireThick=WireThick, WireRad=WireRad, LayerSetGap=LayerGap, LayerSetIdx=0, LayerGap=LayerGap, WindingType=1, CoilSetIdx=0, LenRegion=Model_Length, InfoCoil=4)
  Ph3_P1_C14_1.rotate(axis=Z, angle=22.5deg)
  Ph3_P1_C18_1 [Copper (Pure)_20C [ref. Temp]] = user_primitive(RMxprt/HairpinCoil.dll, DiaGap=DiaGap_Hairpin, DiaYoke=DiaStatorYoke, Length=Stator_Lam_Length, Skew=StatorSkewAngle, Slots=SlotNumber_Stator, SlotType=SlotType_Stator, Hs0=Hs0_Stator, Hs1=Hs1_Stator, Hs2=Hs2_Stator, Bs0=Bs0_Stator, Bs1=Bs1_Stator, Bs2=Bs2_Stator, Rs=Rs_Stator, FilletType=1, Layers=Layers, CoilPitch=-6, EndExt=WdgExt_Avg, SpanExt/SpanGap=SpanExt_F, SegAngle=SegAngle_Coil_Armature, 1stPitch=0, 2ndPitch=6, 2ndSpanExt/SpanGap=SpanExt_R, WireWidth=WireWidth, WireThick=WireThick, WireRad=WireRad, LayerSetGap=LayerGap, LayerSetIdx=1, LayerGap=LayerGap, WindingType=1, CoilSetIdx=0, LenRegion=Model_Length, InfoCoil=4)
  Ph3_P1_C18_1.rotate(axis=Z, angle=15deg)
  Ph3_P1_C22_1 [Copper (Pure)_20C [ref. Temp]] = user_primitive(RMxprt/HairpinCoil.dll, DiaGap=DiaGap_Hairpin, DiaYoke=DiaStatorYoke, Length=Stator_Lam_Length, Skew=StatorSkewAngle, Slots=SlotNumber_Stator, SlotType=SlotType_Stator, Hs0=Hs0_Stator, Hs1=Hs1_Stator, Hs2=Hs2_Stator, Bs0=Bs0_Stator, Bs1=Bs1_Stator, Bs2=Bs2_Stator, Rs=Rs_Stator, FilletType=1, Layers=Layers, CoilPitch=-6, EndExt=WdgExt_Avg, SpanExt/SpanGap=SpanExt_F, SegAngle=SegAngle_Coil_Armature, 1stPitch=0, 2ndPitch=6, 2ndSpanExt/SpanGap=SpanExt_R, WireWidth=WireWidth, WireThick=WireThick, WireRad=WireRad, LayerSetGap=LayerGap, LayerSetIdx=2, LayerGap=LayerGap, WindingType=1, CoilSetIdx=0, LenRegion=Model_Length, InfoCoil=4)
  Ph3_P1_C22_1.rotate(axis=Z, angle=22.5deg)
  Ph3_P2_C3_1 = user_primitive(RMxprt/HairpinCoil.dll, DiaGap=DiaGap_Hairpin, DiaYoke=DiaStatorYoke, Length=Stator_Lam_Length, Skew=StatorSkewAngle, Slots=SlotNumber_Stator, SlotType=SlotType_Stator, Hs0=Hs0_Stator, Hs1=Hs1_Stator, Hs2=Hs2_Stator, Bs0=Bs0_Stator, Bs1=Bs1_Stator, Bs2=Bs2_Stator, Rs=Rs_Stator, FilletType=1, Layers=Layers, CoilPitch=-6, EndExt=WdgExt_Avg, SpanExt/SpanGap=SpanExt_F, SegAngle=SegAngle_Coil_Armature, 1stPitch=0, 2ndPitch=6, 2ndSpanExt/SpanGap=SpanExt_R, WireWidth=WireWidth, WireThick=WireThick, WireRad=WireRad, LayerSetGap=LayerGap, LayerSetIdx=0, LayerGap=LayerGap, WindingType=1, CoilSetIdx=0, LenRegion=Model_Length, InfoCoil=4)
  Ph3_P2_C3_1.rotate(axis=Z, angle=60deg)
  Ph3_P2_C7_1 = user_primitive(RMxprt/HairpinCoil.dll, DiaGap=DiaGap_Hairpin, DiaYoke=DiaStatorYoke, Length=Stator_Lam_Length, Skew=StatorSkewAngle, Slots=SlotNumber_Stator, SlotType=SlotType_Stator, Hs0=Hs0_Stator, Hs1=Hs1_Stator, Hs2=Hs2_Stator, Bs0=Bs0_Stator, Bs1=Bs1_Stator, Bs2=Bs2_Stator, Rs=Rs_Stator, FilletType=1, Layers=Layers, CoilPitch=-6, EndExt=WdgExt_Avg, SpanExt/SpanGap=SpanExt_F, SegAngle=SegAngle_Coil_Armature, 1stPitch=0, 2ndPitch=6, 2ndSpanExt/SpanGap=SpanExt_R, WireWidth=WireWidth, WireThick=WireThick, WireRad=WireRad, LayerSetGap=LayerGap, LayerSetIdx=1, LayerGap=LayerGap, WindingType=1, CoilSetIdx=0, LenRegion=Model_Length, InfoCoil=4)
  Ph3_P2_C7_1.rotate(axis=Z, angle=67.5deg)
  Ph3_P2_C11_1 = user_primitive(RMxprt/HairpinCoil.dll, DiaGap=DiaGap_Hairpin, DiaYoke=DiaStatorYoke, Length=Stator_Lam_Length, Skew=StatorSkewAngle, Slots=SlotNumber_Stator, SlotType=SlotType_Stator, Hs0=Hs0_Stator, Hs1=Hs1_Stator, Hs2=Hs2_Stator, Bs0=Bs0_Stator, Bs1=Bs1_Stator, Bs2=Bs2_Stator, Rs=Rs_Stator, FilletType=1, Layers=Layers, CoilPitch=-6, EndExt=WdgExt_Avg, SpanExt/SpanGap=SpanExt_F, SegAngle=SegAngle_Coil_Armature, 1stPitch=0, 2ndPitch=6, 2ndSpanExt/SpanGap=SpanExt_R, WireWidth=WireWidth, WireThick=WireThick, WireRad=WireRad, LayerSetGap=LayerGap, LayerSetIdx=2, LayerGap=LayerGap, WindingType=1, CoilSetIdx=0, LenRegion=Model_Length, InfoCoil=4)
  Ph3_P2_C11_1.rotate(axis=Z, angle=60deg)
  Ph3_P2_C15_1 = user_primitive(RMxprt/HairpinCoil.dll, DiaGap=DiaGap_Hairpin, DiaYoke=DiaStatorYoke, Length=Stator_Lam_Length, Skew=StatorSkewAngle, Slots=SlotNumber_Stator, SlotType=SlotType_Stator, Hs0=Hs0_Stator, Hs1=Hs1_Stator, Hs2=Hs2_Stator, Bs0=Bs0_Stator, Bs1=Bs1_Stator, Bs2=Bs2_Stator, Rs=Rs_Stator, FilletType=1, Layers=Layers, CoilPitch=-6, EndExt=WdgExt_Avg, SpanExt/SpanGap=SpanExt_F, SegAngle=SegAngle_Coil_Armature, 1stPitch=0, 2ndPitch=6, 2ndSpanExt/SpanGap=SpanExt_R, WireWidth=WireWidth, WireThick=WireThick, WireRad=WireRad, LayerSetGap=LayerGap, LayerSetIdx=0, LayerGap=LayerGap, WindingType=1, CoilSetIdx=0, LenRegion=Model_Length, InfoCoil=4)
  Ph3_P2_C15_1.rotate(axis=Z, angle=67.5deg)
  Ph3_P2_C19_1 = user_primitive(RMxprt/HairpinCoil.dll, DiaGap=DiaGap_Hairpin, DiaYoke=DiaStatorYoke, Length=Stator_Lam_Length, Skew=StatorSkewAngle, Slots=SlotNumber_Stator, SlotType=SlotType_Stator, Hs0=Hs0_Stator, Hs1=Hs1_Stator, Hs2=Hs2_Stator, Bs0=Bs0_Stator, Bs1=Bs1_Stator, Bs2=Bs2_Stator, Rs=Rs_Stator, FilletType=1, Layers=Layers, CoilPitch=-6, EndExt=WdgExt_Avg, SpanExt/SpanGap=SpanExt_F, SegAngle=SegAngle_Coil_Armature, 1stPitch=0, 2ndPitch=6, 2ndSpanExt/SpanGap=SpanExt_R, WireWidth=WireWidth, WireThick=WireThick, WireRad=WireRad, LayerSetGap=LayerGap, LayerSetIdx=1, LayerGap=LayerGap, WindingType=1, CoilSetIdx=0, LenRegion=Model_Length, InfoCoil=4)
  Ph3_P2_C19_1.rotate(axis=Z, angle=60deg)
  Ph3_P2_C23_1 = user_primitive(RMxprt/HairpinCoil.dll, DiaGap=DiaGap_Hairpin, DiaYoke=DiaStatorYoke, Length=Stator_Lam_Length, Skew=StatorSkewAngle, Slots=SlotNumber_Stator, SlotType=SlotType_Stator, Hs0=Hs0_Stator, Hs1=Hs1_Stator, Hs2=Hs2_Stator, Bs0=Bs0_Stator, Bs1=Bs1_Stator, Bs2=Bs2_Stator, Rs=Rs_Stator, FilletType=1, Layers=Layers, CoilPitch=-6, EndExt=WdgExt_Avg, SpanExt/SpanGap=SpanExt_F, SegAngle=SegAngle_Coil_Armature, 1stPitch=0, 2ndPitch=6, 2ndSpanExt/SpanGap=SpanExt_R, WireWidth=WireWidth, WireThick=WireThick, WireRad=WireRad, LayerSetGap=LayerGap, LayerSetIdx=2, LayerGap=LayerGap, WindingType=1, CoilSetIdx=0, LenRegion=Model_Length, InfoCoil=4)
  Ph3_P2_C23_1.rotate(axis=Z, angle=67.5deg)
  Ph1_P1_C1_2 [Copper (Pure)_20C [ref. Temp]] = Ph1_P1_C1_1.separate_bodies()
  Ph1_P1_C1_1.delete()
  Ph1_P1_C5_2 [Copper (Pure)_20C [ref. Temp]] = Ph1_P1_C5_1.separate_bodies()
  Ph1_P1_C5_1.delete()
  Ph1_P1_C9_2 [Copper (Pure)_20C [ref. Temp]] = Ph1_P1_C9_1.separate_bodies()
  Ph1_P1_C9_1.delete()
  Ph1_P1_C13_2 [Copper (Pure)_20C [ref. Temp]] = Ph1_P1_C13_1.separate_bodies()
  Ph1_P1_C13_1.delete()
  Ph1_P1_C17_2 [Copper (Pure)_20C [ref. Temp]] = Ph1_P1_C17_1.separate_bodies()
  Ph1_P1_C17_1.delete()
  Ph1_P1_C21_2 [Copper (Pure)_20C [ref. Temp]] = Ph1_P1_C21_1.separate_bodies()
  Ph1_P1_C21_1.delete()
  Ph1_P2_C1_1.separate_bodies()
  Ph1_P2_C5_1.separate_bodies()
  Ph1_P2_C9_1.separate_bodies()
  Ph1_P2_C13_1.separate_bodies()
  Ph1_P2_C17_1.separate_bodies()
  Ph1_P2_C21_1.separate_bodies()
  Ph2_P1_C4_2 [Copper (Pure)_20C [ref. Temp]] = Ph2_P1_C4_1.separate_bodies()
  Ph2_P1_C4_1.delete()
  Ph2_P1_C8_2 [Copper (Pure)_20C [ref. Temp]] = Ph2_P1_C8_1.separate_bodies()
  Ph2_P1_C8_1.delete()
  Ph2_P1_C12_2 [Copper (Pure)_20C [ref. Temp]] = Ph2_P1_C12_1.separate_bodies()
  Ph2_P1_C12_1.delete()
  Ph2_P1_C16_2 [Copper (Pure)_20C [ref. Temp]] = Ph2_P1_C16_1.separate_bodies()
  Ph2_P1_C16_1.delete()
  Ph2_P1_C20_2 [Copper (Pure)_20C [ref. Temp]] = Ph2_P1_C20_1.separate_bodies()
  Ph2_P1_C20_1.delete()
  Ph2_P1_C24_2 [Copper (Pure)_20C [ref. Temp]] = Ph2_P1_C24_1.separate_bodies()
  Ph2_P1_C24_1.delete()
  Ph2_P2_C2_1.separate_bodies()
  Ph2_P2_C6_1.separate_bodies()
  Ph2_P2_C10_1.separate_bodies()
  Ph2_P2_C14_1.separate_bodies()
  Ph2_P2_C18_1.separate_bodies()
  Ph2_P2_C22_1.separate_bodies()
  Ph3_P1_C2_1.separate_bodies()
  Ph3_P1_C6_1.separate_bodies()
  Ph3_P1_C10_1.separate_bodies()
  Ph3_P1_C14_1.separate_bodies()
  Ph3_P1_C18_1.separate_bodies()
  Ph3_P1_C22_1.separate_bodies()
  Ph3_P2_C3_2 [Copper (Pure)_20C [ref. Temp]] = Ph3_P2_C3_1.separate_bodies()
  Ph3_P2_C3_1.delete()
  Ph3_P2_C7_2 [Copper (Pure)_20C [ref. Temp]] = Ph3_P2_C7_1.separate_bodies()
  Ph3_P2_C7_1.delete()
  Ph3_P2_C11_2 [Copper (Pure)_20C [ref. Temp]] = Ph3_P2_C11_1.separate_bodies()
  Ph3_P2_C11_1.delete()
  Ph3_P2_C15_2 [Copper (Pure)_20C [ref. Temp]] = Ph3_P2_C15_1.separate_bodies()
  Ph3_P2_C15_1.delete()
  Ph3_P2_C19_2 [Copper (Pure)_20C [ref. Temp]] = Ph3_P2_C19_1.separate_bodies()
  Ph3_P2_C19_1.delete()
  Ph3_P2_C23_2 [Copper (Pure)_20C [ref. Temp]] = Ph3_P2_C23_1.separate_bodies()
  Ph3_P2_C23_1.delete()
  coordinate_system CS_L1_1Magnet2S3_1 = origin=(-58.472644mm, 12.359773mm, 0mm) x=(0.67097875mm, -1.0137383mm, 0mm) y=(1.0137383mm, 0.67097875mm, 0mm)
  coordinate_system CS_L1_1Magnet2N3_1 = origin=(-50.086083mm, -32.606724mm, 0mm) x=(-1.1912749mm, 0.24236761mm, 0mm) y=(-0.24236761mm, -1.1912749mm, 0mm)
  coordinate_system CS_L1_1Magnet2N2_1 = origin=(-32.606724mm, 50.086083mm, 0mm) x=(0.24236761mm, 1.1912749mm, 0mm) y=(-1.1912749mm, 0.24236761mm, 0mm)
  coordinate_system CS_L1_1Magnet2S4_1 = origin=(-12.359773mm, -58.472644mm, 0mm) x=(1.0137383mm, 0.67097875mm, 0mm) y=(-0.67097875mm, 1.0137383mm, 0mm)
  coordinate_system CS_L1_1Magnet2S2_1 = origin=(12.359773mm, 58.472644mm, 0mm) x=(-1.0137383mm, -0.67097875mm, 0mm) y=(0.67097875mm, -1.0137383mm, 0mm)
  coordinate_system CS_L1_1Magnet2N4_1 = origin=(32.606724mm, -50.086083mm, 0mm) x=(-0.24236761mm, -1.1912749mm, 0mm) y=(1.1912749mm, -0.24236761mm, 0mm)
  coordinate_system CS_L1_1Magnet2S1_1 = origin=(58.472644mm, -12.359773mm, 0mm) x=(-0.67097875mm, 1.0137383mm, 0mm) y=(-1.0137383mm, -0.67097875mm, 0mm)
  coordinate_system CS_L1_1Magnet1N3_1 = origin=(-58.472644mm, -12.359773mm, 0mm) x=(-0.67097875mm, -1.0137383mm, 0mm) y=(1.0137383mm, -0.67097875mm, 0mm)
  coordinate_system CS_L1_1Magnet1S3_1 = origin=(-50.086083mm, 32.606724mm, 0mm) x=(1.1912749mm, 0.24236761mm, 0mm) y=(-0.24236761mm, 1.1912749mm, 0mm)
  coordinate_system CS_L1_1Magnet1S4_1 = origin=(-32.606724mm, -50.086083mm, 0mm) x=(-0.24236761mm, 1.1912749mm, 0mm) y=(-1.1912749mm, -0.24236761mm, 0mm)
  coordinate_system CS_L1_1Magnet1N2_1 = origin=(-12.359773mm, 58.472644mm, 0mm) x=(-1.0137383mm, 0.67097875mm, 0mm) y=(-0.67097875mm, -1.0137383mm, 0mm)
  coordinate_system CS_L1_1Magnet1N4_1 = origin=(12.359773mm, -58.472644mm, 0mm) x=(1.0137383mm, -0.67097875mm, 0mm) y=(0.67097875mm, 1.0137383mm, 0mm)
  coordinate_system CS_L1_1Magnet1S2_1 = origin=(32.606724mm, 50.086083mm, 0mm) x=(0.24236761mm, -1.1912749mm, 0mm) y=(1.1912749mm, 0.24236761mm, 0mm)
  coordinate_system CS_L1_1Magnet1S1_1 = origin=(50.086083mm, -32.606724mm, 0mm) x=(-1.1912749mm, -0.24236761mm, 0mm) y=(0.24236761mm, -1.1912749mm, 0mm)
  coordinate_system CS_L2_1Magnet2S3_1 = origin=(-64.026812mm, 19.530109mm, 0mm) x=(1.07734mm, -0.56321972mm, 0mm) y=(0.56321972mm, 1.07734mm, 0mm)
  coordinate_system CS_L2_1Magnet2N3_1 = origin=(-59.083666mm, -31.463921mm, 0mm) x=(-1.1600509mm, -0.36353791mm, 0mm) y=(0.36353791mm, -1.1600509mm, 0mm)
  coordinate_system CS_L2_1Magnet2N2_1 = origin=(-31.463921mm, 59.083666mm, 0mm) x=(-0.36353791mm, 1.1600509mm, 0mm) y=(-1.1600509mm, -0.36353791mm, 0mm)
  coordinate_system CS_L2_1Magnet2S4_1 = origin=(-19.530109mm, -64.026812mm, 0mm) x=(0.56321972mm, 1.07734mm, 0mm) y=(-1.07734mm, 0.56321972mm, 0mm)
  coordinate_system CS_L2_1Magnet2S2_1 = origin=(19.530109mm, 64.026812mm, 0mm) x=(-0.56321972mm, -1.07734mm, 0mm) y=(1.07734mm, -0.56321972mm, 0mm)
  coordinate_system CS_L2_1Magnet2N4_1 = origin=(31.463921mm, -59.083666mm, 0mm) x=(0.36353791mm, -1.1600509mm, 0mm) y=(1.1600509mm, 0.36353791mm, 0mm)
  coordinate_system CS_L2_1Magnet2S1_1 = origin=(64.026812mm, -19.530109mm, 0mm) x=(-1.07734mm, 0.56321972mm, 0mm) y=(-0.56321972mm, -1.07734mm, 0mm)
  coordinate_system CS_L2_1Magnet1N3_1 = origin=(-64.026812mm, -19.530109mm, 0mm) x=(-1.07734mm, -0.56321972mm, 0mm) y=(0.56321972mm, -1.07734mm, 0mm)
  coordinate_system CS_L2_1Magnet1S3_1 = origin=(-59.083666mm, 31.463921mm, 0mm) x=(1.1600509mm, -0.36353791mm, 0mm) y=(0.36353791mm, 1.1600509mm, 0mm)
  coordinate_system CS_L2_1Magnet1S4_1 = origin=(-31.463921mm, -59.083666mm, 0mm) x=(0.36353791mm, 1.1600509mm, 0mm) y=(-1.1600509mm, 0.36353791mm, 0mm)
  coordinate_system CS_L2_1Magnet1N2_1 = origin=(-19.530109mm, 64.026812mm, 0mm) x=(-0.56321972mm, 1.07734mm, 0mm) y=(-1.07734mm, -0.56321972mm, 0mm)
  coordinate_system CS_L2_1Magnet1N4_1 = origin=(19.530109mm, -64.026812mm, 0mm) x=(0.56321972mm, -1.07734mm, 0mm) y=(1.07734mm, 0.56321972mm, 0mm)
  coordinate_system CS_L2_1Magnet1S2_1 = origin=(31.463921mm, 59.083666mm, 0mm) x=(-0.36353791mm, -1.1600509mm, 0mm) y=(1.1600509mm, -0.36353791mm, 0mm)
  coordinate_system CS_L2_1Magnet1S1_1 = origin=(59.083666mm, -31.463921mm, 0mm) x=(-1.1600509mm, 0.36353791mm, 0mm) y=(-0.36353791mm, -1.1600509mm, 0mm)
  Band_Tool = user_primitive(RMxprt/Band.dll, DiaGap=1mm, DiaYoke=DiaOuter, Length=0mm, SegAngle=SegAngle, Fractions=SymmetryFactor, HalfAxial=HalfAxial, InfoCore=1)
  Whole_Region [vacuum] = user_primitive(RMxprt/Band.dll, DiaGap=DiaGap+Airgap, DiaYoke=DiaOuter, Length=0mm, SegAngle=SegAngle, Fractions=SymmetryFactor, HalfAxial=HalfAxial, InfoCore=100)
  Band_Tool_1 = Band_Tool.copy()
  Stator_2.subtract(Band_Tool_1)
  Band_Tool_2 = Band_Tool.copy()
  Rotor_1.subtract(Band_Tool_2)
  Band_Tool_21 = Band_Tool.copy()
  Rotor_Pocket_9.subtract(Band_Tool_21)
  Band_Tool_22 = Band_Tool.copy()
  L1_1Magnet2N1_1.subtract(Band_Tool_22)
  Band_Tool_37 = Band_Tool.copy()
  Rotor_Pocket_17.subtract(Band_Tool_37)
  Band_Tool_38 = Band_Tool.copy()
  L1_1Magnet1N1_1.subtract(Band_Tool_38)
  Band_Tool_49 = Band_Tool.copy()
  Rotor_Pocket_23.subtract(Band_Tool_49)
  Band_Tool_50 = Band_Tool.copy()
  L2_1Magnet2N1_1.subtract(Band_Tool_50)
  Band_Tool_65 = Band_Tool.copy()
  Rotor_Pocket_31.subtract(Band_Tool_65)
  Band_Tool_66 = Band_Tool.copy()
  L2_1Magnet1N1_1.subtract(Band_Tool_66)
  Band_Tool_67 = Band_Tool.copy()
  Shaft.subtract(Band_Tool_67)
  Band_Tool_74 = Band_Tool.copy()
  Ph1_P2_C1_1.subtract(Band_Tool_74)
  Band_Tool_75 = Band_Tool.copy()
  Ph1_P2_C5_1.subtract(Band_Tool_75)
  Band_Tool_76 = Band_Tool.copy()
  Ph1_P2_C9_1.subtract(Band_Tool_76)
  Band_Tool_77 = Band_Tool.copy()
  Ph1_P2_C13_1.subtract(Band_Tool_77)
  Band_Tool_78 = Band_Tool.copy()
  Ph1_P2_C17_1.subtract(Band_Tool_78)
  Band_Tool_79 = Band_Tool.copy()
  Ph1_P2_C21_1.subtract(Band_Tool_79)
  Band_Tool_86 = Band_Tool.copy()
  Ph2_P2_C2_1.subtract(Band_Tool_86)
  Band_Tool_87 = Band_Tool.copy()
  Ph2_P2_C6_1.subtract(Band_Tool_87)
  Band_Tool_88 = Band_Tool.copy()
  Ph2_P2_C10_1.subtract(Band_Tool_88)
  Band_Tool_89 = Band_Tool.copy()
  Ph2_P2_C14_1.subtract(Band_Tool_89)
  Band_Tool_90 = Band_Tool.copy()
  Ph2_P2_C18_1.subtract(Band_Tool_90)
  Band_Tool_91 = Band_Tool.copy()
  Ph2_P2_C22_1.subtract(Band_Tool_91)
  Band_Tool_92 = Band_Tool.copy()
  Ph3_P1_C2_1.subtract(Band_Tool_92)
  Band_Tool_93 = Band_Tool.copy()
  Ph3_P1_C6_1.subtract(Band_Tool_93)
  Band_Tool_94 = Band_Tool.copy()
  Ph3_P1_C10_1.subtract(Band_Tool_94)
  Band_Tool_95 = Band_Tool.copy()
  Ph3_P1_C14_1.subtract(Band_Tool_95)
  Band_Tool_96 = Band_Tool.copy()
  Ph3_P1_C18_1.subtract(Band_Tool_96)
  Band_Tool_97 = Band_Tool.copy()
  Ph3_P1_C22_1.subtract(Band_Tool_97)
  Band_Tool_104 = Band_Tool.copy()
  Ph1_P1_C1_2.subtract(Band_Tool_104)
  Band_Tool_105 = Band_Tool.copy()
  Ph1_P1_C5_2.subtract(Band_Tool_105)
  Band_Tool_106 = Band_Tool.copy()
  Ph1_P1_C9_2.subtract(Band_Tool_106)
  Band_Tool_107 = Band_Tool.copy()
  Ph1_P1_C13_2.subtract(Band_Tool_107)
  Band_Tool_108 = Band_Tool.copy()
  Ph1_P1_C17_2.subtract(Band_Tool_108)
  Band_Tool_109 = Band_Tool.copy()
  Ph1_P1_C21_2.subtract(Band_Tool_109)
  Band_Tool_116 = Band_Tool.copy()
  Ph2_P1_C4_2.subtract(Band_Tool_116)
  Band_Tool_117 = Band_Tool.copy()
  Ph2_P1_C8_2.subtract(Band_Tool_117)
  Band_Tool_118 = Band_Tool.copy()
  Ph2_P1_C12_2.subtract(Band_Tool_118)
  Band_Tool_119 = Band_Tool.copy()
  Ph2_P1_C16_2.subtract(Band_Tool_119)
  Band_Tool_120 = Band_Tool.copy()
  Ph2_P1_C20_2.subtract(Band_Tool_120)
  Band_Tool_121 = Band_Tool.copy()
  Ph2_P1_C24_2.subtract(Band_Tool_121)
  Band_Tool_134 = Band_Tool.copy()
  Ph3_P2_C3_2.subtract(Band_Tool_134)
  Band_Tool_135 = Band_Tool.copy()
  Ph3_P2_C7_2.subtract(Band_Tool_135)
  Band_Tool_136 = Band_Tool.copy()
  Ph3_P2_C11_2.subtract(Band_Tool_136)
  Band_Tool_137 = Band_Tool.copy()
  Ph3_P2_C15_2.subtract(Band_Tool_137)
  Band_Tool_138 = Band_Tool.copy()
  Ph3_P2_C19_2.subtract(Band_Tool_138)
  Band_Tool_139 = Band_Tool.copy()
  Band_Tool.delete()
  Ph3_P2_C23_2.subtract(Band_Tool_139)
  Independent = polyline((0mm, 0mm, 0mm) (99mm, 0mm, 0mm))
  Dependent = polyline((0mm, 0mm, 0mm) (70.003571mm, 70.003571mm, 0mm))
  RotatingBand [vacuum] = circle(normal=Z, centre=(0mm, 0mm, 0mm), radius=DiaGap/2 - Airgap/2, segments=1440)
  Whole_Region1 = user_primitive(RMxprt/Band.dll, DiaGap=DiaGap+Airgap, DiaYoke=DiaOuter, Length=0mm, SegAngle=SegAngle, Fractions=SymmetryFactor, HalfAxial=HalfAxial, InfoCore=100)
  RotatingBand.intersect(Whole_Region1)
  InnerBand [vacuum] = circle(normal=Z, centre=(0mm, 0mm, 0mm), radius=DiaGap/2 - 3*Airgap/4, segments=1440)
  Whole_Region2 = user_primitive(RMxprt/Band.dll, DiaGap=DiaGap+Airgap, DiaYoke=DiaOuter, Length=0mm, SegAngle=SegAngle, Fractions=SymmetryFactor, HalfAxial=HalfAxial, InfoCore=100)
  InnerBand.intersect(Whole_Region2)
  OuterBand [vacuum] = circle(normal=Z, centre=(0mm, 0mm, 0mm), radius=DiaGap/2 - Airgap/4, segments=1440)
  Whole_Region3 = user_primitive(RMxprt/Band.dll, DiaGap=DiaGap+Airgap, DiaYoke=DiaOuter, Length=0mm, SegAngle=SegAngle, Fractions=SymmetryFactor, HalfAxial=HalfAxial, InfoCore=100)
  OuterBand.intersect(Whole_Region3)
  Circle1 = circle(normal=Z, centre=(0mm, 0mm, 0mm), radius=DiaGap/2 + (DiaOuter - DiaGap)/2*(1/7.5))
  Whole_Region4 = user_primitive(RMxprt/Band.dll, DiaGap=DiaGap+Airgap, DiaYoke=DiaOuter, Length=0mm, SegAngle=SegAngle, Fractions=SymmetryFactor, HalfAxial=HalfAxial, InfoCore=100)
  Circle1.intersect(Whole_Region4)
  Stator_1 [NO18-1160_180C_SF0.97] = user_primitive(RMxprt/VentSlotCore.dll, DiaGap=DiaGap, DiaYoke=DiaStatorYoke, Length=Stator_Lam_Length, Skew=StatorSkewAngle, Slots=SlotNumber_Stator, SlotType=SlotType_Stator, Hs0=Hs0_Stator, Hs01=0mm, Hs1=Hs1_Stator, Hs2=12.551463mm, Bs0=Bs0_Stator, Bs1=4.63mm, Bs2=4.63mm, Rs=Rs_Stator, FilletType=FilletType_Stator, HalfSlot=0, VentHoles=0, HoleDiaIn=0mm, HoleDiaOut=0mm, HoleLocIn=0mm, HoleLocOut=0mm, VentDucts=0, DuctWidth=0mm, DuctPitch=0mm, SegAngle=SegAngle, LenRegion=0mm, InfoCore=0)
  Band_Tool1 = user_primitive(RMxprt/Band.dll, DiaGap=1mm, DiaYoke=DiaOuter, Length=0mm, SegAngle=SegAngle, Fractions=SymmetryFactor, HalfAxial=HalfAxial, InfoCore=1)
  Band_Tool_140 = Band_Tool1.copy()
  Stator_1.subtract(Band_Tool_140)
  Band_Tool1.delete()
  Stator_1.intersect(Circle1)
  Stator_Lamination_Primitive1_1 = Stator_1.copy()
  Stator_2.subtract(Stator_Lamination_Primitive1_1)
  Circle2 = circle(normal=Z, centre=(0mm, 0mm, 0mm), radius=66.70832mm)
  Whole_Region5 = user_primitive(RMxprt/Band.dll, DiaGap=DiaGap+Airgap, DiaYoke=DiaOuter, Length=0mm, SegAngle=SegAngle, Fractions=SymmetryFactor, HalfAxial=HalfAxial, InfoCore=100)
  Circle2.intersect(Whole_Region5)
  Rotor_2 [NO18-1160_140C_SF0.97] = circle(normal=Z, centre=(0mm, 0mm, 0mm), radius=70.27mm)
  Rotor_Subtract_11 = circle(normal=Z, centre=(0mm, 0mm, 0mm), radius=23.455mm)
  Rotor_2.subtract(Rotor_Subtract_11)
  Band_Tool2 = user_primitive(RMxprt/Band.dll, DiaGap=1mm, DiaYoke=DiaOuter, Length=0mm, SegAngle=SegAngle, Fractions=SymmetryFactor, HalfAxial=HalfAxial, InfoCore=1)
  Band_Tool_141 = Band_Tool2.copy()
  Rotor_2.subtract(Band_Tool_141)
  Band_Tool2.delete()
  Rotor_2.intersect(Circle2)
  Rotor_2_1 = Rotor_2.copy()
  Rotor_1.subtract(Rotor_2_1)
  Rotor_Pocket_17_1 = Rotor_Pocket_17.copy()
  Rotor_Pocket_23_1 = Rotor_Pocket_23.copy()
  Rotor_Pocket_31_1 = Rotor_Pocket_31.copy()
  Rotor_Pocket_9_1 = Rotor_Pocket_9.copy()
  Rotor_1.subtract(Rotor_Pocket_17_1, Rotor_Pocket_23_1, Rotor_Pocket_31_1, Rotor_Pocket_9_1)
  Rotor_Pocket_17_2 = Rotor_Pocket_17.copy()
  Rotor_Pocket_23_2 = Rotor_Pocket_23.copy()
  Rotor_Pocket_31_2 = Rotor_Pocket_31.copy()
  Rotor_Pocket_9_2 = Rotor_Pocket_9.copy()
  Rotor_2.subtract(Rotor_Pocket_17_2, Rotor_Pocket_23_2, Rotor_Pocket_31_2, Rotor_Pocket_9_2)
  Circle3 = circle(normal=Z, centre=(0mm, 0mm, 0mm), radius=46.097722mm)
  Whole_Region6 = user_primitive(RMxprt/Band.dll, DiaGap=DiaGap+Airgap, DiaYoke=DiaOuter, Length=0mm, SegAngle=SegAngle, Fractions=SymmetryFactor, HalfAxial=HalfAxial, InfoCore=100)
  Circle3.intersect(Whole_Region6)
  Rotor_3 [NO18-1160_140C_SF0.97] = circle(normal=Z, centre=(0mm, 0mm, 0mm), radius=70.27mm)
  Rotor_Subtract_12 = circle(normal=Z, centre=(0mm, 0mm, 0mm), radius=23.455mm)
  Rotor_3.subtract(Rotor_Subtract_12)
  Band_Tool4 = user_primitive(RMxprt/Band.dll, DiaGap=1mm, DiaYoke=DiaOuter, Length=0mm, SegAngle=SegAngle, Fractions=SymmetryFactor, HalfAxial=HalfAxial, InfoCore=1)
  Band_Tool_146 = Band_Tool4.copy()
  Rotor_3.subtract(Band_Tool_146)
  Band_Tool4.delete()
  Circle4 = circle(normal=Z, centre=(0mm, 0mm, 0mm), radius=66.70832mm)
  Whole_Region7 = user_primitive(RMxprt/Band.dll, DiaGap=DiaGap+Airgap, DiaYoke=DiaOuter, Length=0mm, SegAngle=SegAngle, Fractions=SymmetryFactor, HalfAxial=HalfAxial, InfoCore=100)
  Circle4.intersect(Whole_Region7)
  Rotor_3.intersect(Circle4)
  Rotor_Pocket_33 = polyline(z=0mm, xy in mm: (48.7926, 15.8167) (65.0201, 5.076) (65.2645, 4.9142) (65.4432, 4.8128) (65.6339, 4.7368) (66.8645, 4.3417) (67.0909, 4.288) (67.323, 4.27) (68.5542, 4.27) (68.9198, 4.4289) (69.053, 4.8047) (68.9315, 6.3125) (68.7771, 7.8174) (68.6351, 8.2302) (68.3318, 8.5442) (67.6252, 9.0119) (51.8147, 19.4767) (51.6505, 19.5854) (50.9663, 19.8277) (50.2485, 19.7204) (48.3318, 18.9264) (47.4127, 17.6844) (48.0779, 16.2898) (48.7926, 15.8167), closed, covered, Arc from point 2 over 3, Arc from point 5 over 3, Arc from point 8 over 3, Arc from point 10 over 3, Arc from point 12 over 3, Arc from point 17 over 3, Arc from point 20 over 3)
  Band_Tool3 = user_primitive(RMxprt/Band.dll, DiaGap=1mm, DiaYoke=DiaOuter, Length=0mm, SegAngle=SegAngle, Fractions=SymmetryFactor, HalfAxial=HalfAxial, InfoCore=1)
  Band_Tool_142 = Band_Tool3.copy()
  Band_Tool_143 = Band_Tool3.copy()
  Rotor_Pocket_33.subtract(Band_Tool_143)
  Rotor_Pocket_17_3 = Rotor_Pocket_33.copy()
  Rotor_Pocket_34 = polyline(z=0mm, xy in mm: (55.8125, 36.4691) (55.8337, 36.2755) (55.8797, 36.0864) (55.9706, 35.7962) (59.0002, 26.1289) (59.625, 25.4146) (60.5737, 25.3935) (61.4274, 25.7471) (62.0006, 26.2953) (62.0535, 27.0867) (59.0242, 36.7531) (58.7793, 37.5344) (58.7399, 37.6359) (58.6873, 37.7312) (57.9666, 38.8293) (57.2254, 39.9136) (56.9069, 40.098) (56.561, 39.9723) (56.1634, 39.5747) (55.826, 39.0575) (55.7255, 38.4482) (55.8125, 36.4691), closed, covered, Arc from point 0 over 3, Arc from point 4 over 3, Arc from point 7 over 3, Arc from point 11 over 3, Arc from point 13 over 3, Arc from point 15 over 3, Arc from point 18 over 3)
  Band_Tool_144 = Band_Tool3.copy()
  Rotor_Pocket_34.subtract(Band_Tool_144)
  Rotor_Pocket_23_3 = Rotor_Pocket_34.copy()
  Rotor_Pocket_35 = polyline(z=0mm, xy in mm: (64.889, 14.2654) (65.0298, 13.996) (65.131, 13.8296) (65.2529, 13.6778) (66.5909, 12.2169) (67.0928, 11.8571) (67.6971, 11.7299) (68.2594, 11.73) (68.5929, 11.8856) (68.6877, 12.2413) (68.4451, 13.5321) (68.1782, 14.8182) (68.148, 14.9227) (68.1041, 15.0224) (67.7248, 15.748) (63.0316, 24.7252) (62.4346, 25.2474) (61.6417, 25.2297) (60.788, 24.8761) (60.1321, 24.1903) (60.1954, 23.2434) (64.889, 14.2654), closed, covered, Arc from point 1 over 3, Arc from point 4 over 3, Arc from point 7 over 3, Arc from point 9 over 3, Arc from point 11 over 3, Arc from point 15 over 3, Arc from point 18 over 3)
  Band_Tool_145 = Band_Tool3.copy()
  Rotor_Pocket_35.subtract(Band_Tool_145)
  Rotor_Pocket_31_3 = Rotor_Pocket_35.copy()
  Rotor_Pocket_32 = polyline(z=0mm, xy in mm: (45.5148, 22.4775) (46.0306, 21.021) (47.5588, 20.7927) (49.4755, 21.5866) (50.0589, 22.0183) (50.3714, 22.6734) (50.4107, 22.8664) (54.1907, 41.4458) (54.3596, 42.2762) (54.352, 42.7126) (54.1605, 43.1049) (53.2056, 44.2782) (52.2253, 45.4304) (51.8654, 45.6019) (51.4945, 45.4558) (50.6239, 44.5852) (50.4726, 44.4083) (50.3504, 44.2102) (49.7597, 43.0607) (49.6785, 42.8721) (49.6239, 42.6741) (49.5654, 42.3868) (45.6857, 23.3175) (45.5148, 22.4775), closed, covered, Arc from point 0 over 3, Arc from point 3 over 3, Arc from point 8 over 3, Arc from point 10 over 3, Arc from point 12 over 3, Arc from point 15 over 3, Arc from point 18 over 3)
  Rotor_Pocket_32.subtract(Band_Tool_142)
  Rotor_Pocket_9_3 = Rotor_Pocket_32.copy()
  Rotor_3.subtract(Rotor_Pocket_17_3, Rotor_Pocket_23_3, Rotor_Pocket_31_3, Rotor_Pocket_9_3)
  [Rotor_Pocket_32..Rotor_Pocket_35, Band_Tool3].delete()
  Rotor_3.intersect(Circle3)
  Rotor_3_1 = Rotor_3.copy()
  Rotor_2.subtract(Rotor_3_1)
motion:
  MotionSetup1: Band Move_Type=Rotate Coordinate_System=Global Axis=Z Is_Positive=true InitPos=InitialPositionMD Angular_Velocity=MachineRPM Objects=RotatingBand
  Moving1: Moving Objects=[Rotor_1, Rotor_Pocket_9, L1_1Magnet2N1_1, Rotor_Pocket_17, L1_1Magnet1N1_1, Rotor_Pocket_23, L2_1Magnet2N1_1, Rotor_Pocket_31, L2_1Magnet1N1_1, Shaft, InnerBand, Rotor_2, Rotor_3]
boundaries and excitations:
  Independent1: Independent Edges=Independent.edge(at (49.5, 0, 0))
  Dependent1: Dependent Edges=Dependent.edge(at (35.0018, 35.0018, 0)) Independent=Independent1 RelationIsSame=false
  VectorPotential1: Vector Potential Edges=Whole_Region.edge(at (91.4641, 37.8857, 0)) Value=0
  CT_Ph1_P1_C1_Go: Coil Objects=Ph1_P1_C1_2 Conductor_number=1 Winding=WG_Ph1_P1 PolarityType=Positive
  CT_Ph1_P1_C5_Go: Coil Objects=Ph1_P1_C5_2 Conductor_number=1 Winding=WG_Ph1_P1 PolarityType=Positive
  CT_Ph1_P1_C9_Go: Coil Objects=Ph1_P1_C9_2 Conductor_number=1 Winding=WG_Ph1_P1 PolarityType=Positive
  CT_Ph1_P1_C13_Go: Coil Objects=Ph1_P1_C13_2 Conductor_number=1 Winding=WG_Ph1_P1 PolarityType=Positive
  CT_Ph1_P1_C17_Go: Coil Objects=Ph1_P1_C17_2 Conductor_number=1 Winding=WG_Ph1_P1 PolarityType=Positive
  CT_Ph1_P1_C21_Go: Coil Objects=Ph1_P1_C21_2 Conductor_number=1 Winding=WG_Ph1_P1 PolarityType=Positive
  CT_Ph1_P2_C1_Go: Coil Objects=Ph1_P2_C1_1 Conductor_number=1 Winding=WG_Ph1_P1 PolarityType=Positive
  CT_Ph1_P2_C5_Go: Coil Objects=Ph1_P2_C5_1 Conductor_number=1 Winding=WG_Ph1_P1 PolarityType=Positive
  CT_Ph1_P2_C9_Go: Coil Objects=Ph1_P2_C9_1 Conductor_number=1 Winding=WG_Ph1_P1 PolarityType=Positive
  CT_Ph1_P2_C13_Go: Coil Objects=Ph1_P2_C13_1 Conductor_number=1 Winding=WG_Ph1_P1 PolarityType=Positive
  CT_Ph1_P2_C17_Go: Coil Objects=Ph1_P2_C17_1 Conductor_number=1 Winding=WG_Ph1_P1 PolarityType=Positive
  CT_Ph1_P2_C21_Go: Coil Objects=Ph1_P2_C21_1 Conductor_number=1 Winding=WG_Ph1_P1 PolarityType=Positive
  CT_Ph2_P1_C4_Go: Coil Objects=Ph2_P1_C4_2 Conductor_number=1 Winding=WG_Ph2_P1 PolarityType=Positive
  CT_Ph2_P1_C8_Go: Coil Objects=Ph2_P1_C8_2 Conductor_number=1 Winding=WG_Ph2_P1 PolarityType=Positive
  CT_Ph2_P1_C12_Go: Coil Objects=Ph2_P1_C12_2 Conductor_number=1 Winding=WG_Ph2_P1 PolarityType=Positive
  CT_Ph2_P1_C16_Go: Coil Objects=Ph2_P1_C16_2 Conductor_number=1 Winding=WG_Ph2_P1 PolarityType=Positive
  CT_Ph2_P1_C20_Go: Coil Objects=Ph2_P1_C20_2 Conductor_number=1 Winding=WG_Ph2_P1 PolarityType=Positive
  CT_Ph2_P1_C24_Go: Coil Objects=Ph2_P1_C24_2 Conductor_number=1 Winding=WG_Ph2_P1 PolarityType=Positive
  CT_Ph2_P2_C2_Go: Coil Objects=Ph2_P2_C2_1 Conductor_number=1 Winding=WG_Ph2_P1 PolarityType=Positive
  CT_Ph2_P2_C6_Go: Coil Objects=Ph2_P2_C6_1 Conductor_number=1 Winding=WG_Ph2_P1 PolarityType=Positive
  CT_Ph2_P2_C10_Go: Coil Objects=Ph2_P2_C10_1 Conductor_number=1 Winding=WG_Ph2_P1 PolarityType=Positive
  CT_Ph2_P2_C14_Go: Coil Objects=Ph2_P2_C14_1 Conductor_number=1 Winding=WG_Ph2_P1 PolarityType=Positive
  CT_Ph2_P2_C18_Go: Coil Objects=Ph2_P2_C18_1 Conductor_number=1 Winding=WG_Ph2_P1 PolarityType=Positive
  CT_Ph2_P2_C22_Go: Coil Objects=Ph2_P2_C22_1 Conductor_number=1 Winding=WG_Ph2_P1 PolarityType=Positive
  CT_Ph3_P1_C2_Ret: Coil Objects=Ph3_P1_C2_1 Conductor_number=1 Winding=WG_Ph3_P1 PolarityType=Negative
  CT_Ph3_P1_C6_Ret: Coil Objects=Ph3_P1_C6_1 Conductor_number=1 Winding=WG_Ph3_P1 PolarityType=Negative
  CT_Ph3_P1_C10_Ret: Coil Objects=Ph3_P1_C10_1 Conductor_number=1 Winding=WG_Ph3_P1 PolarityType=Negative
  CT_Ph3_P1_C14_Ret: Coil Objects=Ph3_P1_C14_1 Conductor_number=1 Winding=WG_Ph3_P1 PolarityType=Negative
  CT_Ph3_P1_C18_Ret: Coil Objects=Ph3_P1_C18_1 Conductor_number=1 Winding=WG_Ph3_P1 PolarityType=Negative
  CT_Ph3_P1_C22_Ret: Coil Objects=Ph3_P1_C22_1 Conductor_number=1 Winding=WG_Ph3_P1 PolarityType=Negative
  CT_Ph3_P2_C3_Ret: Coil Objects=Ph3_P2_C3_2 Conductor_number=1 Winding=WG_Ph3_P1 PolarityType=Negative
  CT_Ph3_P2_C7_Ret: Coil Objects=Ph3_P2_C7_2 Conductor_number=1 Winding=WG_Ph3_P1 PolarityType=Negative
  CT_Ph3_P2_C11_Ret: Coil Objects=Ph3_P2_C11_2 Conductor_number=1 Winding=WG_Ph3_P1 PolarityType=Negative
  CT_Ph3_P2_C15_Ret: Coil Objects=Ph3_P2_C15_2 Conductor_number=1 Winding=WG_Ph3_P1 PolarityType=Negative
  CT_Ph3_P2_C19_Ret: Coil Objects=Ph3_P2_C19_2 Conductor_number=1 Winding=WG_Ph3_P1 PolarityType=Negative
  CT_Ph3_P2_C23_Ret: Coil Objects=Ph3_P2_C23_2 Conductor_number=1 Winding=WG_Ph3_P1 PolarityType=Negative
  L1_1Magnet2N1_1: Current Objects=L1_1Magnet2N1_1 Current=0A IsSolid=true IsPositive=true
  L1_1Magnet1N1_1: Current Objects=L1_1Magnet1N1_1 Current=0A IsSolid=true IsPositive=true
  L2_1Magnet2N1_1: Current Objects=L2_1Magnet2N1_1 Current=0A IsSolid=true IsPositive=true
  L2_1Magnet1N1_1: Current Objects=L2_1Magnet1N1_1 Current=0A IsSolid=true IsPositive=true
  WG_Ph1_P1: Winding Group Type=Current IsSolid=true Current="IPeak * sin( ( 2 * pi * StatorFrequency * time - 0 / 360 * 2 * pi ) + PhaseAdvance )" ParallelBranchesNum=ParallelPaths
  WG_Ph2_P1: Winding Group Type=Current IsSolid=true Current="IPeak * sin( ( 2 * pi * StatorFrequency * time - 120 / 360 * 2 * pi ) + PhaseAdvance )" ParallelBranchesNum=ParallelPaths
  WG_Ph3_P1: Winding Group Type=Current IsSolid=true Current="IPeak * sin( ( 2 * pi * StatorFrequency * time - 240 / 360 * 2 * pi ) + PhaseAdvance )" ParallelBranchesNum=ParallelPaths
  eddy effects on: L1_1Magnet2N1_1, L1_1Magnet1N1_1, L2_1Magnet2N1_1, L2_1Magnet1N1_1
  core loss on: Stator_2, Rotor_1, Stator_1, Rotor_2, Rotor_3
mesh:
  CylindricalGap1: CylindricalGap Objects=RotatingBand Objects=RotatingBand
  Rotor_1: LengthBased RefineInside Objects=Rotor_1 MaxLength=1mm
  Rotor_2: LengthBased RefineInside Objects=Rotor_2 MaxLength=2mm
  Stator_1: LengthBased RefineInside Objects=Stator_2 MaxLength=2mm
  Stator_2: LengthBased RefineInside Objects=Stator_1 MaxLength=1mm
  Conductors: LengthBased RefineInside Objects=[Ph1_P1_C1_2, Ph1_P1_C5_2, Ph1_P1_C9_2, Ph1_P1_C13_2, Ph1_P1_C17_2, Ph1_P1_C21_2, Ph1_P2_C1_1, Ph1_P2_C5_1, Ph1_P2_C9_1, Ph1_P2_C13_1, Ph1_P2_C17_1, Ph1_P2_C21_1, Ph2_P1_C4_2, Ph2_P1_C8_2, Ph2_P1_C12_2, Ph2_P1_C16_2, Ph2_P1_C20_2, Ph2_P1_C24_2, Ph2_P2_C2_1, Ph2_P2_C6_1, Ph2_P2_C10_1, Ph2_P2_C14_1, Ph2_P2_C18_1, Ph2_P2_C22_1, Ph3_P1_C2_1, Ph3_P1_C6_1, Ph3_P1_C10_1, Ph3_P1_C14_1, Ph3_P1_C18_1, Ph3_P1_C22_1, Ph3_P2_C3_2, Ph3_P2_C7_2, Ph3_P2_C11_2, Ph3_P2_C15_2, Ph3_P2_C19_2, Ph3_P2_C23_2] MaxLength=0.5mm
  Rotor_3: LengthBased RefineInside Objects=Rotor_3 MaxLength=5mm
temperatures:
  Stator_2, Rotor_1, Rotor_Pocket_9, Rotor_Pocket_17, Rotor_Pocket_23, Rotor_Pocket_31, Shaft, Whole_Region, Independent, Dependent, RotatingBand, InnerBand, Whole_Region2, OuterBand, Whole_Region3, Stator_1, Band_Tool1, Band_Tool_140, Rotor_2, Rotor_Subtract_11, Band_Tool2, Band_Tool_141, Rotor_3, Rotor_Pocket_32..Rotor_Pocket_35, Band_Tool3, Band_Tool_142..Band_Tool_145, Circle4, Whole_Region7, Rotor_Subtract_12, Band_Tool4, Band_Tool_146, Rotor_Pocket_17_3, Rotor_Pocket_23_3, Rotor_Pocket_31_3, Rotor_Pocket_9_3: 22cel
  L1_1Magnet2N1_1, L1_1Magnet1N1_1, L2_1Magnet2N1_1, L2_1Magnet1N1_1, Ph1_P2_C1_1, Ph1_P2_C5_1, Ph1_P2_C9_1, Ph1_P2_C13_1, Ph1_P2_C17_1, Ph1_P2_C21_1, Ph2_P2_C2_1, Ph2_P2_C6_1, Ph2_P2_C10_1, Ph2_P2_C14_1, Ph2_P2_C18_1, Ph2_P2_C22_1, Ph3_P1_C2_1, Ph3_P1_C6_1, Ph3_P1_C10_1, Ph3_P1_C14_1, Ph3_P1_C18_1, Ph3_P1_C22_1, Ph1_P1_C1_2, Ph1_P1_C5_2, Ph1_P1_C9_2, Ph1_P1_C13_2, Ph1_P1_C17_2, Ph1_P1_C21_2, Ph2_P1_C4_2, Ph2_P1_C8_2, Ph2_P1_C12_2, Ph2_P1_C16_2, Ph2_P1_C20_2, Ph2_P1_C24_2, Ph3_P2_C3_2, Ph3_P2_C7_2, Ph3_P2_C11_2, Ph3_P2_C15_2, Ph3_P2_C19_2, Ph3_P2_C23_2: 80cel
setups:
  MySetupAuto: Transient NonlinearSolverResidual=1e-08 ScalarPotential="Second Order" StopTime=1/StatorFrequency*1Hz*1s*PeriodMultiplier TimeStep=1/StatorFrequency*1Hz*1s/NumTorquePointsPerCycle OutputPerObjectCoreLoss OutputPerObjectSolidLoss InitialTimeStep=0.002s MinTimeStep=0.001s MaxTimeStep=0.003s TimeStepErrTolerance=0.0001
optimetrics:
  Optimetrics_CD: Parametric InterpolationPoints=0 Sim._Setups=[MySetupAuto]
    sweep AAA: 1.0
    sweep MachineRPM: 15000rpm
    sweep PhaseAdvance: 79.41244351deg
    sweep IPeak: 231.129587A
    table edits: add(2.0, 15000rpm, 75.66628551deg, 308.3753812A) add(3.0, 15000rpm, 75.39984866deg, 411.7977408A) add(4.0, 15000rpm, 77.59084809deg, 578.0743934A) add(5.0, 15000rpm, 78.96214049deg, 645.8155811A)
output variables:
  ThetaED = ((pi * MachineRPM/1rpm*NumPoles / 60*time)) + pi
  Id_peak = 2/3*(InputCurrent(WG_Ph1_P1)*cos(ThetaED)+InputCurrent(WG_Ph2_P1)*cos(ThetaED - 120deg)+InputCurrent(WG_Ph3_P1)*cos(ThetaED - 240deg))
  Iq_peak = 2/3*(InputCurrent(WG_Ph1_P1)*-sin(ThetaED)+InputCurrent(WG_Ph2_P1)*-sin(ThetaED - 120deg)+InputCurrent(WG_Ph3_P1)*-sin(ThetaED - 240deg))
  PsiD = 2/3*(FluxLinkage(WG_Ph1_P1)*cos(ThetaED)+FluxLinkage(WG_Ph2_P1)*cos(ThetaED - 120deg)+FluxLinkage(WG_Ph3_P1)*cos(ThetaED - 240deg))
  PsiQ = 2/3*(FluxLinkage(WG_Ph1_P1)*-sin(ThetaED)+FluxLinkage(WG_Ph2_P1)*-sin(ThetaED - 120deg)+FluxLinkage(WG_Ph3_P1)*-sin(ThetaED - 240deg))
  TorqueDQ = 3/2*NumPoles/2*(PsiD*Iq_peak - PsiQ*Id_peak)
  StatorHy = HysteresisLoss(Stator_1) + HysteresisLoss(Stator_2)
  StatorEddy = EddyCurrentLoss(Stator_1) + EddyCurrentLoss(Stator_2)
  RotorHy = HysteresisLoss(Rotor_1) + HysteresisLoss(Rotor_2) + HysteresisLoss(Rotor_3)
  RotorEddy = EddyCurrentLoss(Rotor_1) + EddyCurrentLoss(Rotor_2) + EddyCurrentLoss(Rotor_3)
  MagLoss = SolidLoss(L1_1Magnet1N1_1) + SolidLoss(L1_1Magnet2N1_1) + SolidLoss(L2_1Magnet1N1_1) + SolidLoss(L2_1Magnet2N1_1)
  WindingLoss = PerWindingSolidLoss(WG_Ph1_P1) + PerWindingSolidLoss(WG_Ph2_P1) + PerWindingSolidLoss(WG_Ph3_P1)
