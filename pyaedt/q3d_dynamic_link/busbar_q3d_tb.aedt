# Ansys Electronics Desktop project, version 2025.2
materials:
  copper: thermal_modifier{Property=conductivity Tref=25cel C1=0.00393 C2=0 TL=-273.15cel TU=1000cel auto_calculation} permeability=0.999991 conductivity=58000000
  vacuum: permittivity=1

design q3d_3ph (Q3D Extractor, model units mm)
options: SParamCalcMethod=EqTransLine Calculate_Lossy_Dielectrics
variables:
  module_length = 140mm
  module_width = 100mm
  base_height = 2mm
  module_height = 30mm
  conner_cut = 15mm
  module_terminal_distance = 15mm
  module_terminal_length = 16mm
  module_terminal_width = 15mm
  busbar_thickness = 3mm
  terminal_length = 20mm
  terminal_extrude = 10mm
  busbar_length = 150mm
  busbar_width = 95mm
  bus_offset = 3mm
  insulation = 1mm
  cap_terminal_distance = 45mm
  cap_terminal_radius = 5mm
  dc_terminal_width = 15mm
  dc_terminal_length = 20mm
  cap_pin_height = 8mm
  cap_diamter = 90mm
  cap_height = 40mm
  cap_neck = 2mm
geometry:
  base [copper, non-model] = box(corner=(-module_length /2, -module_width/2, 0mm), size=(module_length/2, module_width/2, base_height))
  body = box(corner=(-module_length /2, -module_width/2, base_height), size=(module_length/2, module_width/2, module_height))
  coordinate_system ObjectCS_module_conner = object of body: Origin=(-70, -50, 32) xAxis{xDirection=1 yDirection=0 zDirection=0} yAxis{xDirection=0 yDirection=1 zDirection=0}
  conner = box(corner=(0mm, 0mm, 0mm), size=(conner_cut, conner_cut, -module_height)) in ObjectCS_module_conner
  coordinate_system ObjectCS_module_mid = object of body: Origin=(-70, 0, 32) xAxis{xDirection=1 yDirection=0 zDirection=0} yAxis{xDirection=0 yDirection=1 zDirection=0} in ObjectCS_module_conner
  terminal [copper, non-model] = box(corner=(2mm, -module_terminal_distance/2, 0mm), size=(module_terminal_length, -module_terminal_width, 3mm)) in ObjectCS_module_mid
  body.subtract(conner)
  body.fillet(Edges=body_2.edge(at (-55, -35, 17)) Radius=8mm Setback=0mm)
  coordinate_system ObjectCS_terminal_conner = object of terminal: Origin=(-68, -22.5, 35) xAxis{xDirection=1 yDirection=0 zDirection=0} yAxis{xDirection=0 yDirection=1 zDirection=0} in ObjectCS_module_conner
  terminal_screw = cylinder(axis=Z, base_centre=(module_terminal_length/2, module_terminal_width/2, 0mm), radius=3mm, height=-8mm) in ObjectCS_terminal_conner
  terminal.subtract(terminal_screw)
  body.fillet(Edges=body_2.edge(at (-55, -50, 17), at (-70, -35, 17)) Radius=3mm Setback=0mm)
  terminal.fillet(Edges=terminal.edge(at (-68, -22.5, 33.5), at (-68, -7.5, 33.5)) Radius=2mm Setback=0mm)
  terminal.fillet(Edges=terminal.edge(at (-52, -15, 35)) Radius=2mm Setback=0mm)
  base.fillet(Edges=base.edge(at (-70, -50, 1)) Radius=5mm Setback=0mm)
  body_cut = box(corner=(0mm, 0mm, module_height+base_height), size=(-module_length/3, -module_width/2.5, -2mm))
  body.subtract(body_cut)
  body.fillet(Edges=body_2.edge(at (-46.6667, -40, 31)) Radius=5mm Setback=0mm)
  base_screw = cylinder(axis=Z, base_centre=(conner_cut/2, conner_cut/2, 0mm), radius=3mm, height=-50mm) in ObjectCS_module_conner
  base.subtract(base_screw)
  base_1 = base.duplicate_mirror(point=(0mm, 0mm, 0mm), normal=(0mm, 1mm, 0mm))
  terminal_1 = terminal.duplicate_mirror(point=(0mm, 0mm, 0mm), normal=(0mm, 1mm, 0mm))
  body_1 = body.duplicate_mirror(point=(0mm, 0mm, 0mm), normal=(0mm, 1mm, 0mm))
  base_2 = base.duplicate_mirror(point=(0mm, 0mm, 0mm), normal=(1mm, 0mm, 0mm))
  body_2 [copper, non-model] = body.duplicate_mirror(point=(0mm, 0mm, 0mm), normal=(1mm, 0mm, 0mm))
  terminal_2 = terminal.duplicate_mirror(point=(0mm, 0mm, 0mm), normal=(1mm, 0mm, 0mm))
  base_1_1 = base_1.duplicate_mirror(point=(0mm, 0mm, 0mm), normal=(1mm, 0mm, 0mm))
  terminal_1_1 = terminal_1.duplicate_mirror(point=(0mm, 0mm, 0mm), normal=(1mm, 0mm, 0mm))
  body_1_1 = body_1.duplicate_mirror(point=(0mm, 0mm, 0mm), normal=(1mm, 0mm, 0mm))
  body_2.unite(body, body_1, body_1_1)
  terminal.unite(terminal_1, terminal_1_1, terminal_2)
  base.unite(base_1, base_1_1, base_2)
  coordinate_system RelativeCS_busbar = origin=(0mm, module_width/2, 3mm) x=(1mm, 0mm, 0mm) y=(0mm, 1mm, 0mm) in ObjectCS_module_conner
  coordinate_system RelativeCS1 = origin=(-230mm, -45mm, 42mm) x=(1mm, 0mm, 0mm) y=(0mm, 1mm, 0mm)
  coordinate_system Relative_rotatte_view = origin=(0mm, 0mm, 0mm) x=(40mm, 80mm, 0mm) y=(-80mm, -120mm, 0mm)
  base_3, base_4 [copper, non-model] = base.duplicate_along_line(step=(0mm, 100mm, 0mm), total=3)
  terminal_3, terminal_4 [copper, non-model] = terminal.duplicate_along_line(step=(0mm, 100mm, 0mm), total=3)
  body_2_1, body_2_2 [copper, non-model] = body_2.duplicate_along_line(step=(0mm, 100mm, 0mm), total=3)
  cap_tool_small, cap_tool_big, cap_tool_small2, cap_tool_small2_1 [copper, non-model] = imported_body()
  cap_a_plus, cap_a_minus, dc_terminal, module_a_minus, module_a_plus, dc_plus, dc_minus [copper] = imported_body()
  Cylinder2_1, Cylinder2_1_1, Cylinder2_1_2 [non-model] = imported_body()
  dc_terminal_1_2, cap_b_minus, cap_c_minus, cap_b_plus, cap_c_plus, module_b_minus, module_c_minus, module_b_plus, module_c_plus [copper] = imported_body()
  list DC_link_bus_bars = dc_terminal, dc_terminal_1_2
  group Module = base, terminal, body_2, base_3, base_4, terminal_3, terminal_4, body_2_1, body_2_2
  group cap1 = Cylinder2_1, Cylinder2_1_1, Cylinder2_1_2
boundaries and excitations:
  dc_plus: SignalNet Objects=dc_terminal
  dc_minus: SignalNet Objects=dc_terminal_1_2
  cap_a_minus: Source Objects=cap_a_minus TerminalType=UniformCurrent Net=dc_minus
  cap_a_plus: Source Objects=cap_a_plus TerminalType=UniformCurrent Net=dc_plus
  dc_minus_1: Sink Objects=dc_minus TerminalType=UniformCurrent Net=dc_minus
  dc_plus_1: Sink Objects=dc_plus TerminalType=UniformCurrent Net=dc_plus
  module_a_minus: Source Objects=module_a_minus TerminalType=UniformCurrent Net=dc_minus
  module_a_plus: Source Objects=module_a_plus TerminalType=UniformCurrent Net=dc_plus
  cap_b_minus: Source Objects=cap_b_minus TerminalType=UniformCurrent Net=dc_minus
  cap_b_plus: Source Objects=cap_b_plus TerminalType=UniformCurrent Net=dc_plus
  module_b_minus: Source Objects=module_b_minus TerminalType=UniformCurrent Net=dc_minus
  module_b_plus: Source Objects=module_b_plus TerminalType=UniformCurrent Net=dc_plus
  cap_c_minus: Source Objects=cap_c_minus TerminalType=UniformCurrent Net=dc_minus
  cap_c_plus: Source Objects=cap_c_plus TerminalType=UniformCurrent Net=dc_plus
  module_c_minus: Source Objects=module_c_minus TerminalType=UniformCurrent Net=dc_minus
  module_c_plus: Source Objects=module_c_plus TerminalType=UniformCurrent Net=dc_plus
mesh:
  Length1: LengthBased Objects=[dc_terminal, dc_terminal_1_2] MaxLength=5mm
  initial mesh: EnablePrime
temperatures:
  base, terminal, body_2, cap_tool_small, cap_tool_big, cap_tool_small2, cap_tool_small2_1, cap_a_plus, cap_a_minus, module_a_minus, module_a_plus, dc_plus, dc_minus, base_3, base_4, terminal_3, terminal_4, body_2_1, body_2_2, Cylinder2_1, Cylinder2_1_1, Cylinder2_1_2, cap_b_minus, cap_c_minus, cap_b_plus, cap_c_plus, module_b_minus, module_c_minus, module_b_plus, module_c_plus: 22cel
  dc_terminal, dc_terminal_1_2: 40cel
setups:
  Setup1: Matrix AdaptiveFreq=500MHz SaveFields DC{Cond{MaxPass=20 MinPass=2 MinConvPass=1 PerError=1 PerRefine=30} Mult{MaxPass=1 MinPass=1 MinConvPass=1 PerError=1 PerRefine=30} AccuracyLevel=Normal} AC{MaxPass=20 MinPass=2 MinConvPass=1 PerError=1 PerRefine=30 ACRLSolverType=ACA} ErrorValue=0.1
    sweep Sweep1: 0Hz to 1Hz step 1Hz; 1Hz to 100MHz, log, 50 per decade; Type=Interpolating InterpTolerance=0.5 InterpMaxSolns=50 MinSolvedFreq=100000
source amplitudes:
  dc_minus:cap_a_minus: AC R/L Fields 1A 0deg
  dc_minus:cap_b_minus, dc_minus:cap_c_minus, dc_minus:module_a_minus, dc_minus:module_b_minus, dc_minus:module_c_minus, dc_plus:cap_a_plus, dc_plus:cap_b_plus, dc_plus:cap_c_plus, dc_plus:module_a_plus, dc_plus:module_b_plus, dc_plus:module_c_plus: AC R/L Fields 0A 0deg
  dc_minus: CG Fields 0V 0deg
  dc_plus: CG Fields 1V 0deg
  dc_minus:cap_a_minus: DC R/L Fields 1A 180deg
  dc_minus:cap_b_minus, dc_minus:cap_c_minus, dc_minus:module_b_minus, dc_minus:module_c_minus, dc_plus:cap_a_plus, dc_plus:cap_b_plus, dc_plus:cap_c_plus, dc_plus:module_a_plus, dc_plus:module_b_plus, dc_plus:module_c_plus: DC R/L Fields 0A 0deg
  dc_minus:module_a_minus: DC R/L Fields 1A 0deg
field calculator expressions:
  P_harmonic_loss = Fundamental_Quantity(32) | EnterVolume(DC_link_bus_bars) | VolumeValue | Integrate
field plots:
  Mesh1, Mesh2: MeshPlots on Setup1 : LastAdaptive at Freq=0.3GHz
reports:
  ACL Matrix Plot 1: ACL(dc_minus:cap_a_minus,dc_minus:cap_a_minus), ACR(dc_minus:cap_a_minus,dc_minus:cap_a_minus) vs Freq on Setup1 : Sweep1
  Calculator Expressions Table 1: P_harmonic_loss vs Freq on Setup1 : LastAdaptive [Phase=0deg]

design 3ph_circuit (Twin Builder)
variables:
  Uref = 150V
  Fref = 100Hz
  Fsw = 15000Hz
  Udc = 400V
  Uload = 205V
  Ph_load = -42.7deg
components:
  Ca = C(UseInitialConditions=true V0=Udc C=1700uF)
  L1 = L(UseInitialConditions=true L=1nH)
  Cb = C(UseInitialConditions=true V0=Udc C=1700uF)
  L2 = L(UseInitialConditions=true L=1nH)
  L3 = L(UseInitialConditions=true L=1nH)
  Cc = C(UseInitialConditions=true V0=Udc C=1700uF)
  L4 = L(UseInitialConditions=true L=0.001H)
  R1 = R(R=0.3ohm)
  D1 = D()
  D2 = D()
  D3 = D()
  D4 = D()
  D5 = D()
  D6 = D()
  L5 = L(UseInitialConditions=true L=0.001H)
  R2 = R(R=0.3ohm)
  L6 = L(UseInitialConditions=true L=0.001H)
  R3 = R(R=0.3ohm)
  E1 = E(EMF=Udc PERIO=0 SPC=1)
  dc_ground = AM()
  R5 = R(R=1mOhm)
  R6 = R(R=1mOhm)
  R7 = R(R=1mOhm)
  module_a_plus_vol = VM()
  module_a_minus_vol = VM()
  module_b_plus_vol = VM()
  module_b_minus_vol = VM()
  module_c_plus_vol = VM()
  module_c_minus_vol = VM()
  R4 = R(R=1mOhm)
  L7 = L(UseInitialConditions=true L=2uH)
  Vdc_plus = VM()
  sinea = sine(ampl=Uref freq=Fref)
  sineb = sine(phase=-120deg ampl=Uref freq=Fref)
  sinec = sine(phase=120deg ampl=Uref freq=Fref)
  Ec = E(Type=ESINE AMPL=Uload FREQ=Fref PERIO=0 PHASE=77.3deg TPERIO=Tend+1 SPC=1)
  Eb = E(Type=ESINE AMPL=Uload FREQ=Fref PERIO=0 PHASE=-162.7deg TPERIO=Tend+1 SPC=1)
  Ea = E(Type=ESINE AMPL=Uload FREQ=Fref PERIO=0 PHASE=-42.7deg SPC=1 TPERIO=Tend+1)
  C4 = C(C=20nF)  # Inactive_Open
  C1 = C(C=20nF)  # Inactive_Open
  C2 = C(C=20nF)  # Inactive_Open
  Vdc_minus = VM()
  SIMPARAM1 = SIMPARAM()
  abc2abz1 = abc2abz(b=sineb.val a=sinea.val c=sinec.val)
  svpwm1 = svpwm(freq=Fsw dead_time=0u v_alpha=abc2abz1.alpha v_beta=abc2abz1.beta t1=0 t2=0 t3=0 t4=0 t5=0 t6=0 v_dc=Udc)
  IGBT1 = IGBT(CTRL=svpwm1.t1)
  IGBT2 = IGBT(CTRL=svpwm1.t2)
  IGBT3 = IGBT(CTRL=svpwm1.t3)
  IGBT4 = IGBT(CTRL=svpwm1.t4)
  IGBT5 = IGBT(CTRL=svpwm1.t5)
  IGBT6 = IGBT(CTRL=svpwm1.t6)
nets:
  0: Vdc_plus.1, module_a_minus_vol.1, module_a_plus_vol.1, Vdc_minus.1, module_b_plus_vol.1, module_c_minus_vol.1, module_b_minus_vol.1, module_c_plus_vol.1, dc_ground.0
  cap_a_minus: R7.1
  cap_a_plus: Ca.0
  cap_b_minus: R6.1
  cap_b_plus: Cb.0
  cap_c_minus: R5.1
  cap_c_plus: Cc.0
  dc_minus_1: E1.0, Vdc_minus.0, dc_ground.1
  dc_plus_1: R4.0, Vdc_plus.0
  module_a_minus: module_a_minus_vol.0, C4.1, D2.0, IGBT2.1
  module_a_plus: C4.0, module_a_plus_vol.0, IGBT1.0, D1.1
  module_b_minus: C1.1, IGBT4.1, D4.0, module_b_minus_vol.0
  module_b_plus: C1.0, D3.1, module_b_plus_vol.0, IGBT3.0
  module_c_minus: IGBT6.1, C2.1, D6.0, module_c_minus_vol.0
  module_c_plus: IGBT5.0, C2.0, D5.1, module_c_plus_vol.0
  net_12: R2.0, L5.1
  net_13: D3.0, IGBT4.0, D4.1, IGBT3.1, L5.0
  net_14: IGBT6.0, IGBT5.1, D6.1, D5.0, L6.0
  net_26: L4.0, D2.1, IGBT1.1, IGBT2.0, D1.0
  net_27: L4.1, R1.0
  net_38: L7.1, E1.1
  net_39: R7.0, L1.1
  net_4: Cb.1, L2.0
  net_40: R6.0, L2.1
  net_41: R5.0, L3.1
  net_42: L7.0, R4.1
  net_44: sineb.val, abc2abz1.b
  net_45: sinea.val, abc2abz1.a
  net_46: sinec.val, abc2abz1.c
  net_47: svpwm1.v_alpha, abc2abz1.alpha
  net_48: svpwm1.v_beta, abc2abz1.beta
  net_49: Eb.0, Ec.0, Ea.0
  net_54: Ec.1, R3.1
  net_55: R1.1, Ea.1
  net_56: Eb.1, R2.1
  net_6: L6.1, R3.0
  net_7: L1.0, Ca.1
  net_8: L3.0, Cc.1
setups:
  TR: TransientData(30ms, 0.01us, 0.2us, false, "")
  Options: ModifiedOptions{ts_reltolflag ts_reltol=0.1 ts_convschflag gen_adv_log=none gen_newsparsematrixflag}
