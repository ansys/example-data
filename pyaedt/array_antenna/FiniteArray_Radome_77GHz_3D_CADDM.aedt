# Ansys Electronics Desktop project, version 2021.1
materials:
  vacuum: permittivity=1
  Rogers RT/duroid 5880 (tm): permittivity=2.2 dielectric_loss_tangent=0.0009
  Teflon (tm): permittivity=2.1 dielectric_loss_tangent=0.001
  copper: permeability=0.999991 conductivity=58000000

design 4X4_MultiCell_CA-Array (HFSS, DrivenModal, model units mm)
options: Save_Adaptive_support_files
variables:
  ScanFrequency = 77000000000Hz
  ScanAngleTheta = 30deg
  ScanAnglePhi = 0deg
  ScanPhaseShiftA = -((ScanFrequency*3.59287718049e-11*sin(ScanAngleTheta)*cos(ScanAnglePhi)) + (ScanFrequency*0.0*sin(ScanAngleTheta)*sin(ScanAnglePhi))) rad
  ScanPhaseShiftB = -((ScanFrequency*0.0*sin(ScanAngleTheta)*cos(ScanAnglePhi)) + (ScanFrequency*3.59287718049e-11*sin(ScanAngleTheta)*sin(ScanAnglePhi))) rad
  ScanMag1 = 1W
  ScanPhase1 = 0deg
geometry:
  3DC_Cell_Radome_In1 = component(3DC_Cell_Radome_In, 3D_Component_File_Path="D:/backedup/Projects/Open Examples/Documentation/HFSS Models/Final Shared/Corrected Luke Fu/Shared/After Peter Krenz Rec/3DComponents/3DC_77GHz_In.a3dcomp", Radome_Thickness=0.2mm, feedY=0.0285cm, coax_inner_rad=0.003cm, patchY=0.114cm, subY="(((3e8/77e9)*100)*0.44) cm", subH=0.0254cm, Radome_Height=1mm, frequency=77GHz, Theta_Scan=0deg, Phi_Scan=0deg)
  sub [Rogers RT/duroid 5880 (tm)] = part_of(3DC_Cell_Radome_In1)
  Ground, antenna, Region, Rectangle1 [vacuum] = part_of(3DC_Cell_Radome_In1)
  Radome [Teflon (tm)] = part_of(3DC_Cell_Radome_In1)
  3DC_77GHz_Corner1_Sub1 = component(3DC_77GHz_Corner1_Sub, 3D_Component_File_Path="D:/backedup/Projects/Open Examples/Documentation/HFSS Models/Final Shared/Corrected Luke Fu/Shared/After Peter Krenz Rec/3DComponents/3DC_77GHz_Corner.a3dcomp", Radome_Thickness=0.2mm, subY="(((3e8/77e9)*100)*0.44) cm", subH=0.0254cm, frequency=77GHz, RadomeHeight=1mm, Theta_Scan=0deg, Phi_Scan=0deg)
  Region_1 [vacuum] = part_of(3DC_77GHz_Corner1_Sub1)
  Radome1 [Teflon (tm)] = part_of(3DC_77GHz_Corner1_Sub1)
  sub_1 [Rogers RT/duroid 5880 (tm)] = part_of(3DC_77GHz_Corner1_Sub1)
  Ground_1 [vacuum] = part_of(3DC_77GHz_Corner1_Sub1)
  Top_GND1 [Rogers RT/duroid 5880 (tm)] = part_of(3DC_77GHz_Corner1_Sub1)
  3DC_77GHz_Side1_Sub1 = component(3DC_77GHz_Side1_Sub, 3D_Component_File_Path="D:/backedup/Projects/Open Examples/Documentation/HFSS Models/Final Shared/Corrected Luke Fu/Shared/After Peter Krenz Rec/3DComponents/3DC_77GHz_Side.a3dcomp", Radome_Thickness=0.2mm, subY="(((3e8/77e9)*100)*0.44) cm", subH=0.0254cm, frequency=77GHz, RadomeHeight=1mm, Theta_Scan=0deg, Phi_Scan=0deg)
  Region_3 [vacuum] = part_of(3DC_77GHz_Side1_Sub1)
  sub_3 [Rogers RT/duroid 5880 (tm)] = part_of(3DC_77GHz_Side1_Sub1)
  Ground_3 [vacuum] = part_of(3DC_77GHz_Side1_Sub1)
  Top_GND1_1 [Rogers RT/duroid 5880 (tm)] = part_of(3DC_77GHz_Side1_Sub1)
  Radome1_ObjectFromFace2 [Teflon (tm)] = part_of(3DC_77GHz_Side1_Sub1)
  3DC_Array_77GHz_Empty_Cell1 = component(3DC_Array_77GHz_Empty_Cell, 3D_Component_File_Path="D:/backedup/Projects/Open Examples/Documentation/HFSS Models/Final Shared/Corrected Luke Fu/Shared/After Peter Krenz Rec/3DComponents/3DC_Array_77GHz_Empty_Cell.a3dcomp", Theta_Scan=0deg, Phi_Scan=0deg)
  Box1 [vacuum] = part_of(3DC_Array_77GHz_Empty_Cell1)
  3DC_Cell_Radome_In1.move(TranslateVectorX=-0.0025714286 TranslateVectorY=-0.0025714286 TranslateVectorZ=0)
  3DC_77GHz_Corner1_Sub1.move(TranslateVectorX=-4.2857143mm TranslateVectorY=-4.2857143mm TranslateVectorZ=1.110223e-16mm)
  3DC_77GHz_Side1_Sub1.move(TranslateVectorX=-0.0025714286 TranslateVectorY=-0.0042857143 TranslateVectorZ=0)
  3DC_Array_77GHz_Empty_Cell1.move(TranslateVectorX=-6mm TranslateVectorY=-6mm TranslateVectorZ=1.4432899e-15mm)
  coordinate_system Top_Radome_CS = origin=(0mm, 0mm, 1.454mm) x=(1mm, 0mm, 0mm) y=(0mm, 1mm, 0mm)
  coordinate_system Top_Substrate_CS = origin=(0mm, 0mm, 0.254mm) x=(1mm, 0mm, 0mm) y=(0mm, 1mm, 0mm)
boundaries and excitations:
  3DC_Cell_Radome_In1_Ant_GND_Metal: Finite Conductivity Objects=[antenna, Ground] UseMaterial Material=3DC_Cell_Radome_In1:copper IsInternal
  3DC_Cell_Radome_In1_LatticePair1: Lattice Pair Faces=Region.face(#67, #69) CoordSysVector{Region.vertex(#84) -> Region.vertex(#89)} ReverseV PhaseDelay=UseScanAngle Phi=0deg Theta=0deg
  3DC_Cell_Radome_In1_LatticePair2: Lattice Pair Faces=Region.face(#66, #68) CoordSysVector{Region.vertex(#85) -> Region.vertex(#88)} ReverseV PhaseDelay=UseScanAngle Phi=0deg Theta=0deg
  3DC_Cell_Radome_In1_Rad1: Radiation Faces=Region.face(#64, #65)
  3DC_77GHz_Corner1_Sub1_Top_Bottom_GND: Finite Conductivity Objects=[Ground_1, Top_GND1] UseMaterial Material=3DC_77GHz_Corner1_Sub1:copper IsInternal
  3DC_77GHz_Corner1_Sub1_LatticePair1: Lattice Pair Faces=Region_1.face(#139, #137) CoordSysVector{Region_1.vertex(#152) -> Region_1.vertex(#157)} PhaseDelay=UseScanAngle Phi=0deg Theta=0deg
  3DC_77GHz_Corner1_Sub1_LatticePair2: Lattice Pair Faces=Region_1.face(#138, #136) CoordSysVector{Region_1.vertex(#153) -> Region_1.vertex(#156)} PhaseDelay=UseScanAngle Phi=0deg Theta=0deg
  3DC_77GHz_Corner1_Sub1_Rad1: Radiation Faces=Region_1.face(#134, #135)
  3DC_77GHz_Side1_Sub1_Top_Bottom_GND: Finite Conductivity Objects=[Ground_3, Top_GND1_1] UseMaterial Material=3DC_77GHz_Side1_Sub1:copper IsInternal
  3DC_77GHz_Side1_Sub1_LatticePair1: Lattice Pair Faces=Region_3.face(#405, #407) CoordSysVector{Region_3.vertex(#422) -> Region_3.vertex(#427)} ReverseV PhaseDelay=UseScanAngle Phi=0deg Theta=0deg
  3DC_77GHz_Side1_Sub1_LatticePair2: Lattice Pair Faces=Region_3.face(#406, #404) CoordSysVector{Region_3.vertex(#421) -> Region_3.vertex(#424)} PhaseDelay=UseScanAngle Phi=0deg Theta=0deg
  3DC_77GHz_Side1_Sub1_Rad1: Radiation Faces=Region_3.face(#402, #403)
  3DC_Array_77GHz_Empty_Cell1_LatticePair1: Lattice Pair Faces=Box1.face(#532, #534) CoordSysVector{Box1.vertex(#549) -> Box1.vertex(#554)} ReverseV PhaseDelay=UseScanAngle Phi=0deg Theta=0deg
  3DC_Array_77GHz_Empty_Cell1_LatticePair2: Lattice Pair Faces=Box1.face(#531, #533) CoordSysVector{Box1.vertex(#550) -> Box1.vertex(#553)} ReverseV PhaseDelay=UseScanAngle Phi=0deg Theta=0deg
  3DC_Array_77GHz_Empty_Cell1_Rad1: Radiation Faces=Box1.face(#529, #530)
  3DC_Cell_Radome_In1_1: Lumped Port Objects=Rectangle1 Modes{Mode1{IntLine{middle of Rectangle1.edge(#93) -> middle of Rectangle1.edge(#95)} CharImp=Zpi RenormImp=50ohm}} Impedance=50ohm
array:
  Type="3D Component" Name=Array UseAirObjects RowPrimaryBnd=3DC_Cell_Radome_In1_LatticePair1 ColumnPrimaryBnd=3DC_Cell_Radome_In1_LatticePair2 RowDimension=8 ColumnDimension=8 RenderType=0 Padding=0 ComponentList(5, 127, 395, 526)
  UseAbove
setups:
  Setup1: HfssDriven Frequency=77GHz MaxDeltaS=0.02 MaximumPasses=1 MinimumPasses=1 MinimumConvergedPasses=1 PercentRefinement=30 BasisOrder=1 PortAccuracy=2 UseDomains DDMSolverResidual=0.0001 SaveRadFieldsOnly
    sweep Sweep: 76GHz to 77GHz, 2 points; Type=Discrete SaveFields
source amplitudes:
  3DC_Cell_Radome_In1_1:1..3DC_Cell_Radome_In1_1:15: 0W 0deg
  3DC_Cell_Radome_In1_1:16: 1W 0deg
radiation setups:
  3D: Infinite Sphere Theta=-180deg..180deg step 1deg Phi=0deg..360deg step 1deg CoordSystem=Top_Radome_CS
  Elevation: Infinite Sphere Theta=-180deg..180deg step 1deg Phi=0deg..90deg step 90deg CoordSystem=Top_Radome_CS
  Infinite Sphere1: Infinite Sphere Theta=0deg..180deg step 3deg Phi=-180deg..180deg step 3deg CoordSystem=Top_Radome_CS
reports:
  3D Polar Plot Realized Gain: dB(RealizedGainTotal) vs Phi, Theta on Setup1 : LastAdaptive, 3D [Freq=77GHz]
  Realized Gain Plot Beam Steered Phi=0: dB(RealizedGainTotal) vs Theta on Setup1 : LastAdaptive, Elevation [Phi=0deg Freq=all]; dB(RealizedGainTotal) vs Theta
  Realized Gain Plot Beam Steered Phi=90: dB(RealizedGainTotal) vs Theta on Setup1 : LastAdaptive, Elevation [Phi=90deg Freq=all]
  Realized Gain Plot as per ScanAngleTheta: dB(RealizedGainTotal) vs Theta on Setup1 : LastAdaptive, 3D [Phi=0deg Freq=77GHz ScanAngleTheta=all]
  Peak Realized Gain Plot Phi=0 as per ScanAngleTheta: dB(RealizedGainTotal) vs Theta on Setup1 : LastAdaptive, Elevation [Phi=0deg Freq=77GHz ScanAngleTheta=all]
  Peak Realized Gain Plot Phi=90 as per ScanAngleTheta: dB(RealizedGainTotal) vs Theta on Setup1 : LastAdaptive, Elevation [Phi=90deg Freq=77GHz ScanAngleTheta=all]
  S Parameter Table: dB(S(Array[4,4]3DC_Cell_Radome_In1_1,Array[4,4]3DC_Cell_Radome_In1_1)), dB(S(Array[4,5]3DC_Cell_Radome_In1_1,Array[4,5]3DC_Cell_Radome_In1_1)), dB(S(Array[5,4]3DC_Cell_Radome_In1_1,Array[5,4]3DC_Cell_Radome_In1_1)), dB(S(Array[5,5]3DC_Cell_Radome_In1_1,Array[5,5]3DC_Cell_Radome_In1_1)) vs Freq on Setup1 : LastAdaptive
  Active S Parameter Table 1: dB(ActiveS(Array[4,4]3DC_Cell_Radome_In1_1:1)), dB(ActiveS(Array[4,5]3DC_Cell_Radome_In1_1:1)), dB(ActiveS(Array[5,4]3DC_Cell_Radome_In1_1:1)), dB(ActiveS(Array[5,5]3DC_Cell_Radome_In1_1:1)) vs Freq on Setup1 : LastAdaptive
