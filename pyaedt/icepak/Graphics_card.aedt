# Ansys Electronics Desktop project, version 2024.1
project datasets:
  $Ceramic_material_39: (-273.15, 0.067032967) (-196.15, 0.067032967) (99.85, 1) (726.85, 1)
materials:
  Al-Extruded: thermal_conductivity=205 mass_density=2800 specific_heat=900 thermal_material_type=Solid
  air: permittivity=1.0006 permeability=1.0000004 thermal_conductivity=0.0261 mass_density=1.1614 specific_heat=1005 thermal_expansion_coefficient=0.00333 thermal_material_type=Fluid diffusivity=2.88e-05 molecular_mass=0.028966 viscosity=1.84e-05 material_refractive_index=1.000293
  PCB_Material: thermal_conductivity{anisotropic component1=20 component2=2 component3=20} mass_density=1 specific_heat=1 thermal_expansion_coefficient=1
  Ceramic_material: thermal_modifier{Property=specific_heat free_form_value=pwl($Ceramic_material_39,Temp)} thermal_conductivity=15 mass_density=3970 specific_heat=910 thermal_material_type=Solid
surface materials:
  Steel-oxidised-surface: surface_emissivity=0.8

design IcepakDesign1 (Icepak, SteadyState TemperatureAndFlow, model units mm)
options: Default_Fluid_Material=air Default_Solid_Material=Al-Extruded Default_Surface_Material=Steel-Oxidised-surface AmbientTemperature=20cel AmbientPressure=0n_per_meter_sq AmbientRadiationTemperature=20cel Gravity_Vector_CS_ID=Global Gravity_Vector_Axis=Y Positive=false Altitude=0meter
geometry:
  Region [air] = region(percentage_offset=50 on all sides)
  SERIAL_PORT [Al-Extruded, surface Steel-oxidised-surface] = imported_body(D:\AnsysEM\AnsysEM18.1\Win64\Examples\Icepak\Graphics Card\graphics_card_simple.stp)
  MEMORY1, MEMORY1_1 [Ceramic_material, surface Steel-oxidised-surface] = imported_body(D:\AnsysEM\AnsysEM18.1\Win64\Examples\Icepak\Graphics Card\graphics_card_simple.stp)
  CAPACITOR [Al-Extruded, surface Steel-oxidised-surface] = imported_body(D:\AnsysEM\AnsysEM18.1\Win64\Examples\Icepak\Graphics Card\graphics_card_simple.stp)
  CAPACITOR_1 [Ceramic_material, surface Steel-oxidised-surface] = imported_body(D:\AnsysEM\AnsysEM18.1\Win64\Examples\Icepak\Graphics Card\graphics_card_simple.stp)
  KB, HEAT_SINK [Al-Extruded, surface Steel-oxidised-surface] = imported_body(D:\AnsysEM\AnsysEM18.1\Win64\Examples\Icepak\Graphics Card\graphics_card_simple.stp)
  CPU [Ceramic_material, surface Steel-oxidised-surface] = imported_body(D:\AnsysEM\AnsysEM18.1\Win64\Examples\Icepak\Graphics Card\graphics_card_simple.stp)
  ALPHA_MAIN_PCB [PCB_Material, surface Steel-oxidised-surface] = imported_body(D:\AnsysEM\AnsysEM18.1\Win64\Examples\Icepak\Graphics Card\graphics_card_simple.stp)
  point CPU_Monitor = (-37mm, 3.086mm, -43mm)
  point Memory_Monitor = (-35mm, 3.6mm, -86mm)
  point Point1 = (80mm, 14.243mm, -55mm)
  plane Plane1 = base (0mm, 1.6mm, -55mm) normal (0mm, 0mm, 5mm)
  group graphics_card_simple = SERIAL_PORT, MEMORY1, MEMORY1_1, CAPACITOR, CAPACITOR_1, KB, HEAT_SINK, CPU, ALPHA_MAIN_PCB
mesh:
  Global:  MeshMethod=MesherHD UserSpecifiedSettings ComputeGap MaxElementSizeX=16mm MaxElementSizeY=3.5mm MaxElementSizeZ=11mm MinElementsInGap=3 MinElementsOnEdge=2 MaxSizeRatio=2 EnableMLM EnforeMLMType=3D MaxLevels=2 BufferLayers=0 UniformMeshParametersType=Average MinGapX=1mm MinGapY=1mm MinGapZ=1mm Objects=Region FacetLevel=3 ProximitySizeFunction CurvatureSizeFunction OptimizePCBMesh
